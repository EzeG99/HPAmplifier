* Extracted by KLayout with SG13G2 LVS runset on : 05/03/2026 03:17

.SUBCKT HPA VSS CMFB|CMFBin|CMFBout VREF IBIAS|I_N IB|I_P VINp|VP VINn|VN
+ VINP|VNin|VNout VINN|VPin|VPout VINP|VOUTN|VOUTP|VOUTn VINN|VOUTN|VOUTP|VOUTp
+ VDD
M$1 \$2 \$5 \$1 VSS sg13_lv_nmos L=6.4u W=96u AS=21.84p AD=21.84p PS=127.28u
+ PD=127.28u
M$17 CMFB|CMFBin|CMFBout CMFB|CMFBin|CMFBout VSS VSS sg13_lv_nmos L=0.2u
+ W=29.97u AS=6.1938p AD=5.6943p PS=37.02u PD=33.39u
M$26 VSS \$13 \$13 VSS sg13_lv_nmos L=0.2u W=29.97u AS=5.6943p AD=6.1938p
+ PS=33.39u PD=37.02u
M$35 VSS \$5 \$5 VSS sg13_lv_nmos L=6.4u W=12u AS=3.18p AD=3.18p PS=19.06u
+ PD=19.06u
M$37 IB|I_P IB|I_P VSS VSS sg13_lv_nmos L=1.06u W=4.8u AS=1.632p AD=1.632p
+ PS=10.28u PD=10.28u
M$38 \$101 IB|I_P VSS VSS sg13_lv_nmos L=1.06u W=4.8u AS=1.632p AD=0.912p
+ PS=10.28u PD=5.18u
M$39 VSS IB|I_P \$116 VSS sg13_lv_nmos L=1.06u W=4.8u AS=0.912p AD=1.632p
+ PS=5.18u PD=10.28u
M$40 \$102 \$102 VSS VSS sg13_lv_nmos L=0.8u W=0.5u AS=0.17p AD=0.17p PS=1.68u
+ PD=1.68u
M$41 VSS \$5 IBIAS|I_N VSS sg13_lv_nmos L=6.5u W=12.5u AS=3.3125p AD=3.3125p
+ PS=19.81u PD=19.81u
M$43 \$5 \$1 \$1 VSS sg13_lv_nmos L=1u W=2u AS=0.68p AD=0.68p PS=4.68u PD=4.68u
M$44 \$104 CMFB|CMFBin|CMFBout VSS VSS sg13_lv_nmos L=0.2u W=179.82u
+ AS=34.6653p AD=34.6653p PS=203.97u PD=203.97u
M$98 VINP|VOUTN|VOUTP|VOUTn IB|I_P VSS VSS sg13_lv_nmos L=1.06u W=264u
+ AS=53.76p AD=53.76p PS=310.4u PD=310.4u
M$109 \$125 \$102 \$121 VSS sg13_lv_nmos L=0.16u W=57u AS=12.255p AD=12.255p
+ PS=79.4u PD=79.4u
M$115 \$104 VINP|VNin|VNout \$125 VSS sg13_lv_nmos L=0.15u W=33u AS=7.095p
+ AD=7.095p PS=51.4u PD=51.4u
M$127 \$104 VINN|VPin|VPout \$126 VSS sg13_lv_nmos L=0.15u W=33u AS=7.095p
+ AD=7.095p PS=51.4u PD=51.4u
M$139 \$126 \$102 \$122 VSS sg13_lv_nmos L=0.16u W=57u AS=12.255p AD=12.255p
+ PS=79.4u PD=79.4u
M$145 VSS IB|I_P VINN|VOUTN|VOUTP|VOUTp VSS sg13_lv_nmos L=1.06u W=264u
+ AS=53.76p AD=53.76p PS=310.4u PD=310.4u
M$328 CMFB|CMFBin|CMFBout VINP|VOUTN|VOUTP|VOUTn \$20 VDD sg13_lv_pmos L=0.35u
+ W=35.98u AS=7.2217p AD=6.8362p PS=49.79u PD=46.62u
M$342 CMFB|CMFBin|CMFBout VINN|VOUTN|VOUTP|VOUTp \$19 VDD sg13_lv_pmos L=0.35u
+ W=35.98u AS=6.8362p AD=7.2217p PS=46.62u PD=49.79u
M$356 \$13 VREF \$20 VDD sg13_lv_pmos L=0.35u W=35.98u AS=7.2217p AD=6.8362p
+ PS=49.79u PD=46.62u
M$370 \$13 VREF \$19 VDD sg13_lv_pmos L=0.35u W=35.98u AS=6.8362p AD=7.2217p
+ PS=46.62u PD=49.79u
M$440 VDD \$1 \$5 VDD sg13_lv_pmos L=2.5u W=12u AS=3.18p AD=2.28p PS=19.06u
+ PD=12.76u
M$442 VDD \$1 \$1 VDD sg13_lv_pmos L=2.5u W=12u AS=2.28p AD=2.28p PS=12.76u
+ PD=12.76u
M$444 VDD \$1 IB|I_P VDD sg13_lv_pmos L=2.5u W=12u AS=2.28p AD=3.18p PS=12.76u
+ PD=19.06u
M$446 VDD IBIAS|I_N \$20 VDD sg13_lv_pmos L=0.7u W=144u AS=28.26p AD=27.36p
+ PS=206.52u PD=198.72u
M$470 VDD IBIAS|I_N \$19 VDD sg13_lv_pmos L=0.7u W=144u AS=27.36p AD=28.26p
+ PS=198.72u PD=206.52u
M$734 VDD IBIAS|I_N IBIAS|I_N VDD sg13_lv_pmos L=0.7u W=48u AS=9.27p AD=9.27p
+ PS=67.54u PD=67.54u
M$782 \$120 \$116 \$121 VDD sg13_lv_pmos L=0.5u W=121.5u AS=26.1225p
+ AD=26.1225p PS=154.65u PD=154.65u
M$788 \$123 \$116 \$122 VDD sg13_lv_pmos L=0.5u W=121.5u AS=26.1225p
+ AD=26.1225p PS=154.65u PD=154.65u
M$794 VDD \$101 \$101 VDD sg13_lv_pmos L=0.35u W=11.2u AS=2.548p AD=2.548p
+ PS=17.64u PD=17.64u
M$810 VDD \$121 VINP|VOUTN|VOUTP|VOUTn VDD sg13_lv_pmos L=0.35u W=342.5u
+ AS=70.2125p AD=70.2125p PS=479.25u PD=479.25u
M$824 \$116 \$116 VDD VDD sg13_lv_pmos L=0.35u W=2.05u AS=0.697p AD=0.3895p
+ PS=4.78u PD=2.43u
M$825 VDD \$116 \$102 VDD sg13_lv_pmos L=0.35u W=2.05u AS=0.3895p AD=0.697p
+ PS=2.43u PD=4.78u
M$826 VDD \$122 VINN|VOUTN|VOUTP|VOUTp VDD sg13_lv_pmos L=0.35u W=342.5u
+ AS=70.2125p AD=70.2125p PS=479.25u PD=479.25u
M$878 VDD \$101 \$120 VDD sg13_lv_pmos L=0.7u W=210u AS=45.15p AD=45.15p
+ PS=257.9u PD=257.9u
M$884 VDD \$101 \$123 VDD sg13_lv_pmos L=0.7u W=210u AS=45.15p AD=45.15p
+ PS=257.9u PD=257.9u
R$1412 \$121 \$636 rppd w=1.5u l=0.55u ps=0 b=0 m=1
R$1413 \$122 \$637 rppd w=1.5u l=0.55u ps=0 b=0 m=1
R$1414 VINN|VPin|VPout VINP|VOUTN|VOUTP|VOUTn rppd w=0.6u l=15.4u ps=0 b=0 m=1
R$1415 VINP|VNin|VNout VINN|VOUTN|VOUTP|VOUTp rppd w=0.6u l=15.4u ps=0 b=0 m=1
R$1416 VINp|VP VINN|VPin|VPout rppd w=0.6u l=6.73u ps=0 b=0 m=1
R$1417 VINn|VN VINP|VNin|VNout rppd w=0.6u l=6.73u ps=0 b=0 m=1
R$1418 VSS \$2 rppd w=1u l=11.5u ps=0 b=0 m=1
C$1419 \$636 VINP|VOUTN|VOUTP|VOUTn cap_cmim w=21.4u l=21.4u A=457.96p P=85.6u
+ m=1
C$1420 \$637 VINN|VOUTN|VOUTP|VOUTp cap_cmim w=21.4u l=21.4u A=457.96p P=85.6u
+ m=1
.ENDS HPA
