* Extracted by KLayout with SG13G2 LVS runset on : 02/03/2026 03:38

.SUBCKT TOP
X$1 VSS VSS via_stack$25
X$2 VSS \$17 VSS \$23 IB IB M14M16
X$3 VSS VSS \$19 M19
X$4 \$19 VSS via_stack$27
X$5 VDD \$23 VDD VDD VSS VDD M15
X$6 VSS \$10 CMFB VSS M0_wBulk
X$7 VSS IB VSS IB M13
X$8 \$23 VSS via_stack$27
X$9 \$17 VSS via_stack$27
X$10 VSS VSS via_stack$25
X$11 VSS VSS via_stack$25
X$12 VSS VSS via_stack$25
X$13 VSS VSS via_stack$25
X$14 VSS VSS via_stack$25
X$15 VSS VSS via_stack$25
X$16 VSS VSS via_stack$25
X$17 VSS VSS via_stack$25
X$18 VSS VSS via_stack$25
X$19 VSS VSS via_stack$25
X$20 VSS VSS via_stack$25
X$21 VSS VSS via_stack$25
X$22 VSS VSS via_stack$25
X$23 VSS VSS via_stack$25
X$24 VSS VSS via_stack$25
X$25 VSS VSS via_stack$25
X$26 VSS VSS via_stack$25
X$27 VSS VSS via_stack$25
X$28 VSS VSS via_stack$25
X$29 VSS VDD via_stack$25
X$30 VSS VDD via_stack$25
X$31 VSS VDD via_stack$25
X$32 VSS VDD via_stack$25
X$33 VSS VDD via_stack$25
X$34 VSS VDD via_stack$25
X$35 VSS VDD via_stack$25
X$36 VSS VDD via_stack$25
X$37 VSS VDD via_stack$25
X$38 VSS VDD via_stack$25
X$39 VSS VDD via_stack$25
X$40 VSS VDD via_stack$25
X$41 VSS VDD via_stack$25
X$42 VSS VDD via_stack$25
X$43 VSS VDD via_stack$25
X$44 VSS VDD via_stack$25
X$45 VSS VDD via_stack$25
X$46 VSS VDD via_stack$25
X$47 VSS VDD via_stack$25
X$48 VSS VDD via_stack$25
X$49 IB VSS via_stack$28
X$50 \$31 VSS via_stack$15
X$51 VSS \$47 \$31 R1R2
X$52 \$47 VSS via_stack$14
X$53 \$34 VSS via_stack$15
X$54 VSS \$49 \$34 R1R2$1
X$55 \$49 VSS via_stack$14
X$56 IB VSS via_stack$18
X$57 IB VSS via_stack$18
X$58 \$19 VSS via_stack$18
X$59 \$19 VSS via_stack$18
X$60 VSS VDD \$I102 VDD \$23 M7M8_wRoutings
X$61 VSS \$31 \$I102 VDD \$17 M5M6_wRoutings
X$62 VSS VDD PMOS_Bulk_right
X$63 \$23 VSS via_stack$18
X$64 \$31 VSS via_stack$13
X$65 \$31 VSS via_stack$13
X$66 \$31 VSS via_stack$13
X$67 \$31 VSS via_stack$13
X$68 \$31 VSS via_stack$13
X$69 \$31 VSS via_stack$13
X$70 \$31 VSS via_stack$13
X$71 \$31 VSS via_stack$13
X$72 \$31 VSS via_stack$13
X$73 \$31 VSS via_stack$13
X$74 \$17 VSS via_stack$18
X$75 \$31 VSS via_stack$12
X$76 VSS VOUTP VDD \$31 VDD M9M10_wRoutings
X$77 \$31 VSS via_stack$12
X$78 VOUTP VSS via_stack$17
X$79 VSS VOUTP \$47 C1C2
X$80 VSS VDD PMOS_Bulk_top
X$81 VSS VDD PMOS_Bulk_left
X$82 VDD VSS via_stack$22
X$83 VDD VSS via_stack$22
X$84 VSS IB VSS VOUTP M11M12_wRoutings
X$85 VDD VSS via_stack$23
X$86 VDD VSS via_stack$23
X$87 VSS VDD via_stack$26
X$88 VSS VDD PMOS_Bulk_top$1
X$89 VSS NMOS_Bulk_bot
X$90 VSS NMOS_Bulk_bot$1
X$91 VSS NMOS_Bulk_right
X$92 VSS VSS via_stack$16
X$93 VSS VSS via_stack$22
X$94 VSS VOUTN \$49 C1C2$1
X$95 \$34 VSS via_stack$12
X$96 VSS VOUTN VDD \$34 VDD M9M10_wRoutings$1
X$97 \$34 VSS via_stack$12
X$98 VOUTN VSS via_stack$17
X$99 VSS VDD PMOS_Bulk_left$1
X$100 VDD VSS via_stack$22
X$101 VDD VSS via_stack$22
X$102 VSS IB VSS VOUTN M11M12_wRoutings$1
X$103 VSS VDD \$I159 VDD \$23 M7M8_wRoutings$1
X$104 VSS \$34 \$I159 VDD \$17 M5M6_wRoutings$1
X$105 \$23 VSS via_stack$18
X$106 VSS VDD PMOS_Bulk_right$1
X$107 \$34 VSS via_stack$13
X$108 \$34 VSS via_stack$13
X$109 \$34 VSS via_stack$13
X$110 \$34 VSS via_stack$13
X$111 \$34 VSS via_stack$13
X$112 \$34 VSS via_stack$13
X$113 \$34 VSS via_stack$13
X$114 \$34 VSS via_stack$13
X$115 \$34 VSS via_stack$13
X$116 \$34 VSS via_stack$13
X$117 \$17 VSS via_stack$18
X$118 VDD VSS via_stack$23
X$119 VDD VSS via_stack$23
X$120 VSS NMOS_Bulk_right$1
X$121 VSS VSS via_stack$16
X$122 VSS VSS via_stack$22
X$123 VSS \$I5 \$10 VINP M1M2_wRoutings
X$124 VSS \$I5 \$31 \$19 M3M4_wRoutings
X$125 VINP VSS via_stack$12
X$126 VINP VSS via_stack$12
X$127 VSS \$I157 \$10 VINN M1M2_wRoutings$1
X$128 \$31 VSS via_stack$13
X$129 \$31 VSS via_stack$13
X$130 \$31 VSS via_stack$13
X$131 \$31 VSS via_stack$13
X$132 \$31 VSS via_stack$13
X$133 \$31 VSS via_stack$13
X$134 \$31 VSS via_stack$13
X$135 \$31 VSS via_stack$13
X$136 \$31 VSS via_stack$13
X$137 \$31 VSS via_stack$13
X$138 VINN VSS via_stack$12
X$139 VINN VSS via_stack$12
X$140 VSS \$I157 \$34 \$19 M3M4_wRoutings$1
X$141 \$34 VSS via_stack$13
X$142 \$34 VSS via_stack$13
X$143 \$34 VSS via_stack$13
X$144 \$34 VSS via_stack$13
X$145 \$34 VSS via_stack$13
X$146 \$34 VSS via_stack$13
X$147 \$34 VSS via_stack$13
X$148 \$34 VSS via_stack$13
X$149 \$34 VSS via_stack$13
X$150 \$34 VSS via_stack$13
X$151 \$17 VSS via_stack$19
X$152 VSS \$19 VDD VDD \$17 M17M18
X$153 VSS VDD VDD \$17 \$17 M17M18
M$1 \$17 \$17 VDD VDD sg13_lv_pmos L=0.35u W=2.05u AS=0.697p AD=0.3895p
+ PS=4.78u PD=2.43u
M$2 VDD \$17 \$19 VDD sg13_lv_pmos L=0.35u W=2.05u AS=0.3895p AD=0.697p
+ PS=2.43u PD=4.78u
.ENDS TOP

.SUBCKT M11M12_wRoutings \$1 \$I6 \$I3 \$I2
X$1 \$1 \$I3 \$I2 \$I3 \$I3 \$I3 \$I2 \$I3 \$I2 \$I3 \$I2 \$I2 \$I2 \$I6 \$I6
+ \$I6 \$I6 \$I6 \$I6 \$I6 \$I6 \$I6 \$I6 \$I6 M11M12
X$2 \$1 \$I2 drainM11M12
X$3 \$1 \$I3 sourceM11M12
X$4 \$1 \$I6 gateM11M12
X$5 \$1 \$I6 gateM11M12
.ENDS M11M12_wRoutings

.SUBCKT M11M12_wRoutings$1 \$1 \$I6 \$I3 \$I2
X$1 \$1 \$I3 \$I2 \$I3 \$I3 \$I3 \$I2 \$I3 \$I2 \$I3 \$I2 \$I2 \$I2 \$I6 \$I6
+ \$I6 \$I6 \$I6 \$I6 \$I6 \$I6 \$I6 \$I6 \$I6 M11M12$1
X$2 \$1 \$I2 drainM11M12$1
X$3 \$1 \$I3 sourceM11M12$1
X$4 \$1 \$I6 gateM11M12$1
X$5 \$1 \$I6 gateM11M12$1
.ENDS M11M12_wRoutings$1

.SUBCKT M3M4_wRoutings$1 \$1 \$2 \$3 \$I15
X$1 \$1 \$3 \$3 \$2 \$3 \$2 \$2 \$2 \$I15 \$I15 \$I15 \$I15 \$I15 \$I15 M3M4$1
X$2 \$1 \$3 drainRowM3M4$1
X$3 \$1 \$3 drainRowM3M4$1
X$4 \$1 \$I15 gateM3M4$1
X$5 \$1 \$I15 gateM3M4$1
X$6 \$2 \$1 via_stack$1
X$7 \$2 \$1 via_stack$1
X$8 \$2 \$1 via_stack$1
X$9 \$2 \$1 via_stack$1
X$10 \$1 \$3 topRowM3M4$1
X$11 \$1 \$2 sourceRowM3M4$1
X$12 \$1 \$2 sourceRowM3M4$1
.ENDS M3M4_wRoutings$1

.SUBCKT via_stack$27 \$1 \$2
.ENDS via_stack$27

.SUBCKT NMOS_Bulk_right$1 \$1
X$1 \$1 M1_Cont1_NMOS$1
X$2 \$1 M1_Cont1_NMOS$1
X$3 \$1 M1_Cont1_NMOS$1
X$4 \$1 M1_Cont1_NMOS$1
X$5 \$1 M1_Cont1_NMOS$1
X$6 \$1 M1_Cont1_NMOS$1
X$7 \$1 M1_Cont1_NMOS$1
X$8 \$1 M1_Cont1_NMOS$1
X$9 \$1 M1_Cont1_NMOS$1
X$10 \$1 M1_Cont1_NMOS$1
X$11 \$1 M1_Cont1_NMOS$1
X$12 \$1 M1_Cont1_NMOS$1
X$13 \$1 M1_Cont1_NMOS$1
X$14 \$1 M1_Cont1_NMOS$1
X$15 \$1 M1_Cont1_NMOS$1
X$16 \$1 M1_Cont1_NMOS$1
X$17 \$1 M1_Cont1_NMOS$1
X$18 \$1 M1_Cont1_NMOS$1
X$19 \$1 M1_Cont1_NMOS$1
X$20 \$1 M1_Cont1_NMOS$1
X$21 \$1 M1_Cont1_NMOS$1
X$22 \$1 M1_Cont1_NMOS$1
X$23 \$1 M1_Cont1_NMOS$1
X$24 \$1 M1_Cont1_NMOS$1
X$25 \$1 M1_Cont1_NMOS$1
X$26 \$1 M1_Cont1_NMOS$1
X$27 \$1 M1_Cont1_NMOS$1
X$28 \$1 M1_Cont1_NMOS$1
X$29 \$1 M1_Cont1_NMOS$1
X$30 \$1 M1_Cont1_NMOS$1
X$31 \$1 M1_Cont1_NMOS$1
X$32 \$1 M1_Cont1_NMOS$1
X$33 \$1 M1_Cont1_NMOS$1
.ENDS NMOS_Bulk_right$1

.SUBCKT PMOS_Bulk_left$1 \$1 \$I1
X$1 \$I1 \$1 M1_Cont1_PMOS$1
X$2 \$I1 \$1 M1_Cont1_PMOS$1
X$3 \$I1 \$1 M1_Cont1_PMOS$1
X$4 \$I1 \$1 M1_Cont1_PMOS$1
X$5 \$I1 \$1 M1_Cont1_PMOS$1
X$6 \$I1 \$1 M1_Cont1_PMOS$1
X$7 \$I1 \$1 M1_Cont1_PMOS$1
X$8 \$I1 \$1 M1_Cont1_PMOS$1
X$9 \$I1 \$1 M1_Cont1_PMOS$1
X$10 \$I1 \$1 M1_Cont1_PMOS$1
X$11 \$I1 \$1 M1_Cont1_PMOS$1
X$12 \$I1 \$1 M1_Cont1_PMOS$1
X$13 \$I1 \$1 M1_Cont1_PMOS$1
X$14 \$I1 \$1 M1_Cont1_PMOS$1
X$15 \$I1 \$1 M1_Cont1_PMOS$1
X$16 \$I1 \$1 M1_Cont1_PMOS$1
X$17 \$I1 \$1 M1_Cont1_PMOS$1
X$18 \$I1 \$1 M1_Cont1_PMOS$1
X$19 \$I1 \$1 M1_Cont1_PMOS$1
X$20 \$I1 \$1 M1_Cont1_PMOS$1
X$21 \$I1 \$1 M1_Cont1_PMOS$1
X$22 \$I1 \$1 M1_Cont1_PMOS$1
X$23 \$I1 \$1 M1_Cont1_PMOS$1
X$24 \$I1 \$1 M1_Cont1_PMOS$1
X$25 \$I1 \$1 M1_Cont1_PMOS$1
X$26 \$I1 \$1 M1_Cont1_PMOS$1
X$27 \$I1 \$1 M1_Cont1_PMOS$1
X$28 \$I1 \$1 M1_Cont1_PMOS$1
X$29 \$I1 \$1 M1_Cont1_PMOS$1
X$30 \$I1 \$1 M1_Cont1_PMOS$1
X$31 \$I1 \$1 M1_Cont1_PMOS$1
X$32 \$I1 \$1 M1_Cont1_PMOS$1
X$33 \$I1 \$1 M1_Cont1_PMOS$1
X$34 \$I1 \$1 M1_Cont1_PMOS$1
X$35 \$I1 \$1 M1_Cont1_PMOS$1
X$36 \$I1 \$1 M1_Cont1_PMOS$1
X$37 \$I1 \$1 M1_Cont1_PMOS$1
X$38 \$I1 \$1 M1_Cont1_PMOS$1
X$39 \$I1 \$1 M1_Cont1_PMOS$1
X$40 \$I1 \$1 M1_Cont1_PMOS$1
X$41 \$I1 \$1 M1_Cont1_PMOS$1
.ENDS PMOS_Bulk_left$1

.SUBCKT NMOS_Bulk_bot$1 \$1
X$1 \$1 M1_Cont1_NMOS$1
X$2 \$1 M1_Cont1_NMOS$1
X$3 \$1 M1_Cont1_NMOS$1
X$4 \$1 M1_Cont1_NMOS$1
X$5 \$1 M1_Cont1_NMOS$1
X$6 \$1 M1_Cont1_NMOS$1
X$7 \$1 M1_Cont1_NMOS$1
X$8 \$1 M1_Cont1_NMOS$1
X$9 \$1 M1_Cont1_NMOS$1
X$10 \$1 M1_Cont1_NMOS$1
X$11 \$1 M1_Cont1_NMOS$1
X$12 \$1 M1_Cont1_NMOS$1
X$13 \$1 M1_Cont1_NMOS$1
X$14 \$1 M1_Cont1_NMOS$1
X$15 \$1 M1_Cont1_NMOS$1
X$16 \$1 M1_Cont1_NMOS$1
X$17 \$1 M1_Cont1_NMOS$1
X$18 \$1 M1_Cont1_NMOS$1
X$19 \$1 M1_Cont1_NMOS$1
X$20 \$1 M1_Cont1_NMOS$1
X$21 \$1 M1_Cont1_NMOS$1
X$22 \$1 M1_Cont1_NMOS$1
X$23 \$1 M1_Cont1_NMOS$1
X$24 \$1 M1_Cont1_NMOS$1
X$25 \$1 M1_Cont1_NMOS$1
X$26 \$1 M1_Cont1_NMOS$1
X$27 \$1 M1_Cont1_NMOS$1
X$28 \$1 M1_Cont1_NMOS$1
X$29 \$1 M1_Cont1_NMOS$1
X$30 \$1 M1_Cont1_NMOS$1
X$31 \$1 M1_Cont1_NMOS$1
X$32 \$1 M1_Cont1_NMOS$1
X$33 \$1 M1_Cont1_NMOS$1
.ENDS NMOS_Bulk_bot$1

.SUBCKT PMOS_Bulk_top$1 \$1 \$I1
X$1 \$I1 \$1 M1_Cont1_PMOS$1
X$2 \$I1 \$1 M1_Cont1_PMOS$1
X$3 \$I1 \$1 M1_Cont1_PMOS$1
X$4 \$I1 \$1 M1_Cont1_PMOS$1
X$5 \$I1 \$1 M1_Cont1_PMOS$1
X$6 \$I1 \$1 M1_Cont1_PMOS$1
X$7 \$I1 \$1 M1_Cont1_PMOS$1
X$8 \$I1 \$1 M1_Cont1_PMOS$1
X$9 \$I1 \$1 M1_Cont1_PMOS$1
X$10 \$I1 \$1 M1_Cont1_PMOS$1
X$11 \$I1 \$1 M1_Cont1_PMOS$1
X$12 \$I1 \$1 M1_Cont1_PMOS$1
X$13 \$I1 \$1 M1_Cont1_PMOS$1
X$14 \$I1 \$1 M1_Cont1_PMOS$1
X$15 \$I1 \$1 M1_Cont1_PMOS$1
X$16 \$I1 \$1 M1_Cont1_PMOS$1
X$17 \$I1 \$1 M1_Cont1_PMOS$1
X$18 \$I1 \$1 M1_Cont1_PMOS$1
X$19 \$I1 \$1 M1_Cont1_PMOS$1
X$20 \$I1 \$1 M1_Cont1_PMOS$1
X$21 \$I1 \$1 M1_Cont1_PMOS$1
X$22 \$I1 \$1 M1_Cont1_PMOS$1
X$23 \$I1 \$1 M1_Cont1_PMOS$1
X$24 \$I1 \$1 M1_Cont1_PMOS$1
X$25 \$I1 \$1 M1_Cont1_PMOS$1
X$26 \$I1 \$1 M1_Cont1_PMOS$1
X$27 \$I1 \$1 M1_Cont1_PMOS$1
X$28 \$I1 \$1 M1_Cont1_PMOS$1
X$29 \$I1 \$1 M1_Cont1_PMOS$1
X$30 \$I1 \$1 M1_Cont1_PMOS$1
X$31 \$I1 \$1 M1_Cont1_PMOS$1
X$32 \$I1 \$1 M1_Cont1_PMOS$1
X$33 \$I1 \$1 M1_Cont1_PMOS$1
X$34 \$I1 \$1 M1_Cont1_PMOS$1
X$35 \$I1 \$1 M1_Cont1_PMOS$1
X$36 \$I1 \$1 M1_Cont1_PMOS$1
X$37 \$I1 \$1 M1_Cont1_PMOS$1
X$38 \$I1 \$1 M1_Cont1_PMOS$1
X$39 \$I1 \$1 M1_Cont1_PMOS$1
X$40 \$I1 \$1 M1_Cont1_PMOS$1
X$41 \$I1 \$1 M1_Cont1_PMOS$1
X$42 \$I1 \$1 M1_Cont1_PMOS$1
X$43 \$I1 \$1 M1_Cont1_PMOS$1
X$44 \$I1 \$1 M1_Cont1_PMOS$1
X$45 \$I1 \$1 M1_Cont1_PMOS$1
X$46 \$I1 \$1 M1_Cont1_PMOS$1
X$47 \$I1 \$1 M1_Cont1_PMOS$1
X$48 \$I1 \$1 M1_Cont1_PMOS$1
X$49 \$I1 \$1 M1_Cont1_PMOS$1
.ENDS PMOS_Bulk_top$1

.SUBCKT PMOS_Bulk_right$1 \$1 \$I1
X$1 \$I1 \$1 M1_Cont1_PMOS$1
X$2 \$I1 \$1 M1_Cont1_PMOS$1
X$3 \$I1 \$1 M1_Cont1_PMOS$1
X$4 \$I1 \$1 M1_Cont1_PMOS$1
X$5 \$I1 \$1 M1_Cont1_PMOS$1
X$6 \$I1 \$1 M1_Cont1_PMOS$1
X$7 \$I1 \$1 M1_Cont1_PMOS$1
X$8 \$I1 \$1 M1_Cont1_PMOS$1
X$9 \$I1 \$1 M1_Cont1_PMOS$1
X$10 \$I1 \$1 M1_Cont1_PMOS$1
X$11 \$I1 \$1 M1_Cont1_PMOS$1
X$12 \$I1 \$1 M1_Cont1_PMOS$1
X$13 \$I1 \$1 M1_Cont1_PMOS$1
X$14 \$I1 \$1 M1_Cont1_PMOS$1
X$15 \$I1 \$1 M1_Cont1_PMOS$1
X$16 \$I1 \$1 M1_Cont1_PMOS$1
X$17 \$I1 \$1 M1_Cont1_PMOS$1
X$18 \$I1 \$1 M1_Cont1_PMOS$1
X$19 \$I1 \$1 M1_Cont1_PMOS$1
X$20 \$I1 \$1 M1_Cont1_PMOS$1
X$21 \$I1 \$1 M1_Cont1_PMOS$1
X$22 \$I1 \$1 M1_Cont1_PMOS$1
X$23 \$I1 \$1 M1_Cont1_PMOS$1
X$24 \$I1 \$1 M1_Cont1_PMOS$1
X$25 \$I1 \$1 M1_Cont1_PMOS$1
X$26 \$I1 \$1 M1_Cont1_PMOS$1
X$27 \$I1 \$1 M1_Cont1_PMOS$1
X$28 \$I1 \$1 M1_Cont1_PMOS$1
X$29 \$I1 \$1 M1_Cont1_PMOS$1
X$30 \$I1 \$1 M1_Cont1_PMOS$1
X$31 \$I1 \$1 M1_Cont1_PMOS$1
X$32 \$I1 \$1 M1_Cont1_PMOS$1
X$33 \$I1 \$1 M1_Cont1_PMOS$1
X$34 \$I1 \$1 M1_Cont1_PMOS$1
.ENDS PMOS_Bulk_right$1

.SUBCKT via_stack$18 \$1 \$2
.ENDS via_stack$18

.SUBCKT M9M10_wRoutings$1 \$1 \$2 \$I17 \$I16 \$I11
X$1 \$2 \$I11 \$I11 \$2 \$2 \$I11 \$2 \$I11 \$I11 \$2 \$I11 \$1 \$I16 \$I16
+ \$I16 \$I16 \$I16 \$I16 \$I16 \$I16 \$I16 \$I16 \$I17 M9M10$1
X$2 \$1 \$I11 drainM9M10$1
X$3 \$1 \$2 sourceM9M10$1
X$4 \$2 \$1 via_stack
X$5 \$2 \$1 via_stack
X$6 \$2 \$1 via_stack
X$7 \$2 \$1 via_stack
X$8 \$2 \$1 via_stack
X$9 \$1 \$I16 gateM9M10$1
X$10 \$1 \$I16 gateM9M10$1
.ENDS M9M10_wRoutings$1

.SUBCKT R1R2$1 \$1 \$I2 \$I1
X$1 \$I1 \$I2 \$1 rppd$1
.ENDS R1R2$1

.SUBCKT M5M6_wRoutings$1 \$1 \$2 \$3 \$I24 \$I21
X$1 \$2 \$2 \$3 \$2 \$3 \$3 \$3 \$1 \$I21 \$I21 \$I21 \$I21 \$I21 \$I21 \$I24
+ M5M6$1
X$2 \$3 \$1 drainRowM5M6$1
X$3 \$3 \$1 drainRowM5M6$1
X$4 \$1 \$I21 gateM5M6$1
X$5 \$3 \$1 via_stack
X$6 \$3 \$1 via_stack
X$7 \$3 \$1 via_stack
X$8 \$3 \$1 via_stack
X$9 \$2 \$1 via_stack
X$10 \$2 \$1 via_stack
X$11 \$2 \$1 via_stack
X$12 \$2 \$1 sourceRowM5M6$1
X$13 \$2 \$1 sourceRowM5M6$1
X$14 \$1 \$I21 gateM5M6$1
.ENDS M5M6_wRoutings$1

.SUBCKT C1C2$1 \$1 \$I2 \$I1
X$1 \$1 \$I1 \$I2 cmim$1
.ENDS C1C2$1

.SUBCKT M7M8_wRoutings$1 \$1 \$2 \$3 \$I25 \$I21
X$1 \$2 \$3 \$2 \$3 \$2 \$3 \$2 \$1 \$I21 \$I21 \$I21 \$I21 \$I21 \$I21 \$I25
+ M7M8$1
X$2 \$2 \$1 drainRowM7M8$1
X$3 \$2 \$1 drainRowM7M8$1
X$4 \$1 \$I21 gateM7M8$1
X$5 \$2 \$1 via_stack$1
X$6 \$2 \$1 via_stack$1
X$7 \$2 \$1 via_stack$1
X$8 \$2 \$1 via_stack$1
X$9 \$3 \$1 sourceRowM7M8$1
X$10 \$3 \$1 sourceRowM7M8$1
X$11 \$1 \$I21 gateM7M8$1
X$12 \$3 \$1 via_stack$1
X$13 \$3 \$1 via_stack$1
X$14 \$3 \$1 via_stack$1
.ENDS M7M8_wRoutings$1

.SUBCKT M1M2_wRoutings$1 \$1 \$2 \$3 \$I23
X$1 \$1 \$3 \$2 \$3 \$2 \$3 \$2 \$3 \$I23 \$I23 \$I23 \$I23 \$I23 \$I23 M1M2$1
X$2 \$1 \$3 drainRowM1M2$1
X$3 \$1 \$3 drainRowM1M2$1
X$4 \$2 \$1 via_stack
X$5 \$2 \$1 via_stack
X$6 \$2 \$1 via_stack
X$7 \$1 \$2 sourceRowM1M2$1
X$8 \$1 \$2 sourceRowM1M2$1
X$9 \$3 \$1 via_stack
X$10 \$3 \$1 via_stack
X$11 \$3 \$1 via_stack
X$12 \$3 \$1 via_stack
X$13 \$1 \$I23 gateM1M2$1
X$14 \$1 \$I23 gateM1M2$1
.ENDS M1M2_wRoutings$1

.SUBCKT via_stack$25 \$1 \$2
.ENDS via_stack$25

.SUBCKT NMOS_Bulk_right \$1
X$1 \$1 M1_Cont1_NMOS
X$2 \$1 M1_Cont1_NMOS
X$3 \$1 M1_Cont1_NMOS
X$4 \$1 M1_Cont1_NMOS
X$5 \$1 M1_Cont1_NMOS
X$6 \$1 M1_Cont1_NMOS
X$7 \$1 M1_Cont1_NMOS
X$8 \$1 M1_Cont1_NMOS
X$9 \$1 M1_Cont1_NMOS
X$10 \$1 M1_Cont1_NMOS
X$11 \$1 M1_Cont1_NMOS
X$12 \$1 M1_Cont1_NMOS
X$13 \$1 M1_Cont1_NMOS
X$14 \$1 M1_Cont1_NMOS
X$15 \$1 M1_Cont1_NMOS
X$16 \$1 M1_Cont1_NMOS
X$17 \$1 M1_Cont1_NMOS
X$18 \$1 M1_Cont1_NMOS
X$19 \$1 M1_Cont1_NMOS
X$20 \$1 M1_Cont1_NMOS
X$21 \$1 M1_Cont1_NMOS
X$22 \$1 M1_Cont1_NMOS
X$23 \$1 M1_Cont1_NMOS
X$24 \$1 M1_Cont1_NMOS
X$25 \$1 M1_Cont1_NMOS
X$26 \$1 M1_Cont1_NMOS
X$27 \$1 M1_Cont1_NMOS
X$28 \$1 M1_Cont1_NMOS
X$29 \$1 M1_Cont1_NMOS
X$30 \$1 M1_Cont1_NMOS
X$31 \$1 M1_Cont1_NMOS
X$32 \$1 M1_Cont1_NMOS
X$33 \$1 M1_Cont1_NMOS
.ENDS NMOS_Bulk_right

.SUBCKT via_stack$26 \$1 \$2
.ENDS via_stack$26

.SUBCKT via_stack$22 \$1 \$2
.ENDS via_stack$22

.SUBCKT via_stack$23 \$1 \$2
.ENDS via_stack$23

.SUBCKT PMOS_Bulk_left \$1 \$I1
X$1 \$I1 \$1 M1_Cont1_PMOS
X$2 \$I1 \$1 M1_Cont1_PMOS
X$3 \$I1 \$1 M1_Cont1_PMOS
X$4 \$I1 \$1 M1_Cont1_PMOS
X$5 \$I1 \$1 M1_Cont1_PMOS
X$6 \$I1 \$1 M1_Cont1_PMOS
X$7 \$I1 \$1 M1_Cont1_PMOS
X$8 \$I1 \$1 M1_Cont1_PMOS
X$9 \$I1 \$1 M1_Cont1_PMOS
X$10 \$I1 \$1 M1_Cont1_PMOS
X$11 \$I1 \$1 M1_Cont1_PMOS
X$12 \$I1 \$1 M1_Cont1_PMOS
X$13 \$I1 \$1 M1_Cont1_PMOS
X$14 \$I1 \$1 M1_Cont1_PMOS
X$15 \$I1 \$1 M1_Cont1_PMOS
X$16 \$I1 \$1 M1_Cont1_PMOS
X$17 \$I1 \$1 M1_Cont1_PMOS
X$18 \$I1 \$1 M1_Cont1_PMOS
X$19 \$I1 \$1 M1_Cont1_PMOS
X$20 \$I1 \$1 M1_Cont1_PMOS
X$21 \$I1 \$1 M1_Cont1_PMOS
X$22 \$I1 \$1 M1_Cont1_PMOS
X$23 \$I1 \$1 M1_Cont1_PMOS
X$24 \$I1 \$1 M1_Cont1_PMOS
X$25 \$I1 \$1 M1_Cont1_PMOS
X$26 \$I1 \$1 M1_Cont1_PMOS
X$27 \$I1 \$1 M1_Cont1_PMOS
X$28 \$I1 \$1 M1_Cont1_PMOS
X$29 \$I1 \$1 M1_Cont1_PMOS
X$30 \$I1 \$1 M1_Cont1_PMOS
X$31 \$I1 \$1 M1_Cont1_PMOS
X$32 \$I1 \$1 M1_Cont1_PMOS
X$33 \$I1 \$1 M1_Cont1_PMOS
X$34 \$I1 \$1 M1_Cont1_PMOS
X$35 \$I1 \$1 M1_Cont1_PMOS
X$36 \$I1 \$1 M1_Cont1_PMOS
X$37 \$I1 \$1 M1_Cont1_PMOS
X$38 \$I1 \$1 M1_Cont1_PMOS
X$39 \$I1 \$1 M1_Cont1_PMOS
X$40 \$I1 \$1 M1_Cont1_PMOS
X$41 \$I1 \$1 M1_Cont1_PMOS
.ENDS PMOS_Bulk_left

.SUBCKT via_stack$16 \$1 \$2
.ENDS via_stack$16

.SUBCKT NMOS_Bulk_bot \$1
X$1 \$1 M1_Cont1_NMOS
X$2 \$1 M1_Cont1_NMOS
X$3 \$1 M1_Cont1_NMOS
X$4 \$1 M1_Cont1_NMOS
X$5 \$1 M1_Cont1_NMOS
X$6 \$1 M1_Cont1_NMOS
X$7 \$1 M1_Cont1_NMOS
X$8 \$1 M1_Cont1_NMOS
X$9 \$1 M1_Cont1_NMOS
X$10 \$1 M1_Cont1_NMOS
X$11 \$1 M1_Cont1_NMOS
X$12 \$1 M1_Cont1_NMOS
X$13 \$1 M1_Cont1_NMOS
X$14 \$1 M1_Cont1_NMOS
X$15 \$1 M1_Cont1_NMOS
X$16 \$1 M1_Cont1_NMOS
X$17 \$1 M1_Cont1_NMOS
X$18 \$1 M1_Cont1_NMOS
X$19 \$1 M1_Cont1_NMOS
X$20 \$1 M1_Cont1_NMOS
X$21 \$1 M1_Cont1_NMOS
X$22 \$1 M1_Cont1_NMOS
X$23 \$1 M1_Cont1_NMOS
X$24 \$1 M1_Cont1_NMOS
X$25 \$1 M1_Cont1_NMOS
X$26 \$1 M1_Cont1_NMOS
X$27 \$1 M1_Cont1_NMOS
X$28 \$1 M1_Cont1_NMOS
X$29 \$1 M1_Cont1_NMOS
X$30 \$1 M1_Cont1_NMOS
X$31 \$1 M1_Cont1_NMOS
X$32 \$1 M1_Cont1_NMOS
X$33 \$1 M1_Cont1_NMOS
.ENDS NMOS_Bulk_bot

.SUBCKT M19 \$1 \$I2 \$I1
X$1 \$I2 \$I1 \$1 nmos$4
.ENDS M19

.SUBCKT M14M16 \$1 \$2 \$3 \$4 \$I11 \$I10
X$1 \$3 \$4 \$1 \$I10 nmos$3
X$2 \$2 \$3 \$1 \$I11 nmos$3
M$1 \$4 \$I10 \$3 \$1 sg13_lv_nmos L=1.06u W=4.8u AS=1.632p AD=0.912p PS=10.28u
+ PD=5.18u
M$2 \$3 \$I11 \$2 \$1 sg13_lv_nmos L=1.06u W=4.8u AS=0.912p AD=1.632p PS=5.18u
+ PD=10.28u
.ENDS M14M16

.SUBCKT M13 \$1 \$2 \$3 \$I4
X$1 \$3 \$2 \$1 \$I4 nmos$3
M$1 \$3 \$I4 \$2 \$1 sg13_lv_nmos L=1.06u W=4.8u AS=1.632p AD=1.632p PS=10.28u
+ PD=10.28u
.ENDS M13

.SUBCKT via_stack$28 \$1 \$2
.ENDS via_stack$28

.SUBCKT M15 \$1 \$2 \$3 \$7 \$11 \$I50
X$1 \$2 \$1 \$I50 \$11 \$2 pmos$4
X$2 \$11 \$1 Cont_M15
X$3 \$2 \$1 \$I50 \$11 \$2 pmos$4
X$4 \$2 \$3 \$I50 \$11 \$2 pmos$4
X$5 \$2 \$11 via_stack$19
X$6 \$3 \$2 \$I50 \$11 \$2 pmos$4
X$7 \$2 \$3 \$I50 \$11 \$2 pmos$4
X$8 \$3 \$2 \$I50 \$11 \$2 pmos$4
X$9 \$7 \$2 \$I50 \$11 \$2 pmos$4
X$10 \$7 \$2 \$I50 \$11 \$2 pmos$4
X$11 \$11 \$2 Cont_M15
X$12 \$11 \$2 Cont_M15
X$13 \$11 \$3 Cont_M15
X$14 \$11 \$7 Cont_M15
M$1 \$7 \$2 \$2 \$I50 sg13_lv_pmos L=0.35u W=1.4u AS=0.476p AD=0.266p PS=3.48u
+ PD=1.78u
M$2 \$2 \$2 \$3 \$I50 sg13_lv_pmos L=0.35u W=1.4u AS=0.266p AD=0.266p PS=1.78u
+ PD=1.78u
M$3 \$3 \$2 \$2 \$I50 sg13_lv_pmos L=0.35u W=1.4u AS=0.266p AD=0.266p PS=1.78u
+ PD=1.78u
M$4 \$2 \$2 \$1 \$I50 sg13_lv_pmos L=0.35u W=1.4u AS=0.266p AD=0.476p PS=1.78u
+ PD=3.48u
M$5 \$7 \$2 \$2 \$I50 sg13_lv_pmos L=0.35u W=1.4u AS=0.476p AD=0.266p PS=3.48u
+ PD=1.78u
M$6 \$2 \$2 \$3 \$I50 sg13_lv_pmos L=0.35u W=1.4u AS=0.266p AD=0.266p PS=1.78u
+ PD=1.78u
M$7 \$3 \$2 \$2 \$I50 sg13_lv_pmos L=0.35u W=1.4u AS=0.266p AD=0.266p PS=1.78u
+ PD=1.78u
M$8 \$2 \$2 \$1 \$I50 sg13_lv_pmos L=0.35u W=1.4u AS=0.266p AD=0.476p PS=1.78u
+ PD=3.48u
.ENDS M15

.SUBCKT M17M18 \$1 \$I4 \$I3 \$I2 \$I1
X$1 \$I4 \$I2 \$I3 \$1 \$I1 pmos$5
.ENDS M17M18

.SUBCKT PMOS_Bulk_top \$1 \$I1
X$1 \$I1 \$1 M1_Cont1_PMOS
X$2 \$I1 \$1 M1_Cont1_PMOS
X$3 \$I1 \$1 M1_Cont1_PMOS
X$4 \$I1 \$1 M1_Cont1_PMOS
X$5 \$I1 \$1 M1_Cont1_PMOS
X$6 \$I1 \$1 M1_Cont1_PMOS
X$7 \$I1 \$1 M1_Cont1_PMOS
X$8 \$I1 \$1 M1_Cont1_PMOS
X$9 \$I1 \$1 M1_Cont1_PMOS
X$10 \$I1 \$1 M1_Cont1_PMOS
X$11 \$I1 \$1 M1_Cont1_PMOS
X$12 \$I1 \$1 M1_Cont1_PMOS
X$13 \$I1 \$1 M1_Cont1_PMOS
X$14 \$I1 \$1 M1_Cont1_PMOS
X$15 \$I1 \$1 M1_Cont1_PMOS
X$16 \$I1 \$1 M1_Cont1_PMOS
X$17 \$I1 \$1 M1_Cont1_PMOS
X$18 \$I1 \$1 M1_Cont1_PMOS
X$19 \$I1 \$1 M1_Cont1_PMOS
X$20 \$I1 \$1 M1_Cont1_PMOS
X$21 \$I1 \$1 M1_Cont1_PMOS
X$22 \$I1 \$1 M1_Cont1_PMOS
X$23 \$I1 \$1 M1_Cont1_PMOS
X$24 \$I1 \$1 M1_Cont1_PMOS
X$25 \$I1 \$1 M1_Cont1_PMOS
X$26 \$I1 \$1 M1_Cont1_PMOS
X$27 \$I1 \$1 M1_Cont1_PMOS
X$28 \$I1 \$1 M1_Cont1_PMOS
X$29 \$I1 \$1 M1_Cont1_PMOS
X$30 \$I1 \$1 M1_Cont1_PMOS
X$31 \$I1 \$1 M1_Cont1_PMOS
X$32 \$I1 \$1 M1_Cont1_PMOS
X$33 \$I1 \$1 M1_Cont1_PMOS
X$34 \$I1 \$1 M1_Cont1_PMOS
X$35 \$I1 \$1 M1_Cont1_PMOS
X$36 \$I1 \$1 M1_Cont1_PMOS
X$37 \$I1 \$1 M1_Cont1_PMOS
X$38 \$I1 \$1 M1_Cont1_PMOS
X$39 \$I1 \$1 M1_Cont1_PMOS
X$40 \$I1 \$1 M1_Cont1_PMOS
X$41 \$I1 \$1 M1_Cont1_PMOS
X$42 \$I1 \$1 M1_Cont1_PMOS
X$43 \$I1 \$1 M1_Cont1_PMOS
X$44 \$I1 \$1 M1_Cont1_PMOS
X$45 \$I1 \$1 M1_Cont1_PMOS
X$46 \$I1 \$1 M1_Cont1_PMOS
X$47 \$I1 \$1 M1_Cont1_PMOS
X$48 \$I1 \$1 M1_Cont1_PMOS
X$49 \$I1 \$1 M1_Cont1_PMOS
.ENDS PMOS_Bulk_top

.SUBCKT PMOS_Bulk_right \$1 \$I1
X$1 \$I1 \$1 M1_Cont1_PMOS
X$2 \$I1 \$1 M1_Cont1_PMOS
X$3 \$I1 \$1 M1_Cont1_PMOS
X$4 \$I1 \$1 M1_Cont1_PMOS
X$5 \$I1 \$1 M1_Cont1_PMOS
X$6 \$I1 \$1 M1_Cont1_PMOS
X$7 \$I1 \$1 M1_Cont1_PMOS
X$8 \$I1 \$1 M1_Cont1_PMOS
X$9 \$I1 \$1 M1_Cont1_PMOS
X$10 \$I1 \$1 M1_Cont1_PMOS
X$11 \$I1 \$1 M1_Cont1_PMOS
X$12 \$I1 \$1 M1_Cont1_PMOS
X$13 \$I1 \$1 M1_Cont1_PMOS
X$14 \$I1 \$1 M1_Cont1_PMOS
X$15 \$I1 \$1 M1_Cont1_PMOS
X$16 \$I1 \$1 M1_Cont1_PMOS
X$17 \$I1 \$1 M1_Cont1_PMOS
X$18 \$I1 \$1 M1_Cont1_PMOS
X$19 \$I1 \$1 M1_Cont1_PMOS
X$20 \$I1 \$1 M1_Cont1_PMOS
X$21 \$I1 \$1 M1_Cont1_PMOS
X$22 \$I1 \$1 M1_Cont1_PMOS
X$23 \$I1 \$1 M1_Cont1_PMOS
X$24 \$I1 \$1 M1_Cont1_PMOS
X$25 \$I1 \$1 M1_Cont1_PMOS
X$26 \$I1 \$1 M1_Cont1_PMOS
X$27 \$I1 \$1 M1_Cont1_PMOS
X$28 \$I1 \$1 M1_Cont1_PMOS
X$29 \$I1 \$1 M1_Cont1_PMOS
X$30 \$I1 \$1 M1_Cont1_PMOS
X$31 \$I1 \$1 M1_Cont1_PMOS
X$32 \$I1 \$1 M1_Cont1_PMOS
X$33 \$I1 \$1 M1_Cont1_PMOS
X$34 \$I1 \$1 M1_Cont1_PMOS
.ENDS PMOS_Bulk_right

.SUBCKT M9M10_wRoutings \$1 \$2 \$I17 \$I16 \$I11
X$1 \$2 \$I11 \$I11 \$2 \$2 \$I11 \$2 \$I11 \$I11 \$2 \$I11 \$1 \$I16 \$I16
+ \$I16 \$I16 \$I16 \$I16 \$I16 \$I16 \$I16 \$I16 \$I17 M9M10
X$2 \$1 \$I11 drainM9M10
X$3 \$1 \$2 sourceM9M10
X$4 \$2 \$1 via_stack
X$5 \$2 \$1 via_stack
X$6 \$2 \$1 via_stack
X$7 \$2 \$1 via_stack
X$8 \$2 \$1 via_stack
X$9 \$1 \$I16 gateM9M10
X$10 \$1 \$I16 gateM9M10
.ENDS M9M10_wRoutings

.SUBCKT via_stack$17 \$1 \$2
.ENDS via_stack$17

.SUBCKT R1R2 \$1 \$I3 \$I2
X$1 \$I2 \$I3 \$1 rppd$1
.ENDS R1R2

.SUBCKT via_stack$14 \$1 \$2
.ENDS via_stack$14

.SUBCKT via_stack$15 \$1 \$2
.ENDS via_stack$15

.SUBCKT via_stack$12 \$1 \$2
.ENDS via_stack$12

.SUBCKT via_stack$13 \$1 \$2
.ENDS via_stack$13

.SUBCKT M5M6_wRoutings \$1 \$2 \$3 \$I24 \$I21
X$1 \$2 \$2 \$3 \$2 \$3 \$3 \$3 \$1 \$I21 \$I21 \$I21 \$I21 \$I21 \$I21 \$I24
+ M5M6
X$2 \$3 \$1 drainRowM5M6
X$3 \$3 \$1 drainRowM5M6
X$4 \$1 \$I21 gateM5M6
X$5 \$3 \$1 via_stack
X$6 \$3 \$1 via_stack
X$7 \$3 \$1 via_stack
X$8 \$3 \$1 via_stack
X$9 \$2 \$1 via_stack
X$10 \$2 \$1 via_stack
X$11 \$2 \$1 via_stack
X$12 \$2 \$1 sourceRowM5M6
X$13 \$2 \$1 sourceRowM5M6
X$14 \$1 \$I21 gateM5M6
.ENDS M5M6_wRoutings

.SUBCKT C1C2 \$1 \$I3 \$I2
X$1 \$1 \$I2 \$I3 cmim$1
.ENDS C1C2

.SUBCKT M7M8_wRoutings \$1 \$2 \$3 \$I25 \$I21
X$1 \$2 \$3 \$2 \$3 \$2 \$3 \$2 \$1 \$I21 \$I21 \$I21 \$I21 \$I21 \$I21 \$I25
+ M7M8
X$2 \$2 \$1 drainRowM7M8
X$3 \$2 \$1 drainRowM7M8
X$4 \$1 \$I21 gateM7M8
X$5 \$2 \$1 via_stack$1
X$6 \$2 \$1 via_stack$1
X$7 \$2 \$1 via_stack$1
X$8 \$2 \$1 via_stack$1
X$9 \$3 \$1 sourceRowM7M8
X$10 \$3 \$1 sourceRowM7M8
X$11 \$1 \$I21 gateM7M8
X$12 \$3 \$1 via_stack$1
X$13 \$3 \$1 via_stack$1
X$14 \$3 \$1 via_stack$1
.ENDS M7M8_wRoutings

.SUBCKT M3M4_wRoutings \$1 \$2 \$3 \$I15
X$1 \$1 \$3 \$3 \$2 \$3 \$2 \$2 \$2 \$I15 \$I15 \$I15 \$I15 \$I15 \$I15 M3M4
X$2 \$1 \$3 drainRowM3M4
X$3 \$1 \$3 drainRowM3M4
X$4 \$1 \$I15 gateM3M4
X$5 \$1 \$I15 gateM3M4
X$6 \$2 \$1 via_stack$1
X$7 \$2 \$1 via_stack$1
X$8 \$2 \$1 via_stack$1
X$9 \$2 \$1 via_stack$1
X$10 \$1 \$3 topRowM3M4
X$11 \$1 \$2 sourceRowM3M4
X$12 \$1 \$2 sourceRowM3M4
.ENDS M3M4_wRoutings

.SUBCKT M1M2_wRoutings \$1 \$2 \$3 \$I23
X$1 \$1 \$3 \$2 \$3 \$2 \$3 \$2 \$3 \$I23 \$I23 \$I23 \$I23 \$I23 \$I23 M1M2
X$2 \$1 \$3 drainRowM1M2
X$3 \$1 \$3 drainRowM1M2
X$4 \$2 \$1 via_stack
X$5 \$2 \$1 via_stack
X$6 \$2 \$1 via_stack
X$7 \$1 \$2 sourceRowM1M2
X$8 \$1 \$2 sourceRowM1M2
X$9 \$3 \$1 via_stack
X$10 \$3 \$1 via_stack
X$11 \$3 \$1 via_stack
X$12 \$3 \$1 via_stack
X$13 \$1 \$I23 gateM1M2
X$14 \$1 \$I23 gateM1M2
.ENDS M1M2_wRoutings

.SUBCKT M0_wBulk \$1 \$I6 \$I5 \$I4
X$1 \$1 \$I6 \$I4 \$I5 M0_wRoutings
X$2 \$1 M0_hor_bulk
X$3 \$1 M0_ver_bulk
X$4 \$1 M0_ver_bulk
X$5 \$1 M0_hor_bulk
.ENDS M0_wBulk

.SUBCKT cmim$1 \$1 \$2 \$3
C$1 \$3 \$2 cap_cmim w=21.4u l=21.4u A=457.96p P=85.6u m=1
.ENDS cmim$1

.SUBCKT rppd$1 \$1 \$2 \$3
R$1 \$1 \$2 rppd w=1.5u l=0.55u ps=0 b=0 m=1
.ENDS rppd$1

.SUBCKT gateM11M12 \$1 \$2
X$1 \$2 \$1 via_stack$6
.ENDS gateM11M12

.SUBCKT sourceM11M12 \$1 \$2
X$1 \$1 \$2 sourceRowM11M12
X$2 \$1 \$2 topRow
X$3 \$1 \$2 sourceRowM11M12
.ENDS sourceM11M12

.SUBCKT drainM11M12 \$1 \$2
X$1 \$1 \$2 drainRowM11M12
X$2 \$1 \$2 drainRowM11M12
X$3 \$1 \$2 topRow
.ENDS drainM11M12

.SUBCKT M11M12 \$1 \$2 \$3 \$4 \$6 \$7 \$8 \$9 \$10 \$16 \$20 \$21 \$34 \$I320
+ \$I315 \$I310 \$I305 \$I300 \$I295 \$I290 \$I285 \$I280 \$I275 \$I271
X$1 \$21 \$4 \$1 \$I271 nmos$3
X$2 \$1 \$21 M1_conM11M12
X$3 \$1 \$4 M1_conM11M12
X$4 \$4 \$34 \$1 \$I275 nmos$3
X$5 \$1 \$34 M1_conM11M12
X$6 \$34 \$2 \$1 \$I280 nmos$3
X$7 \$1 \$2 M1_conM11M12
X$8 \$2 \$10 \$1 \$I285 nmos$3
X$9 \$1 \$10 M1_conM11M12
X$10 \$10 \$7 \$1 \$I290 nmos$3
X$11 \$1 \$7 M1_conM11M12
X$12 \$7 \$3 \$1 \$I295 nmos$3
X$13 \$1 \$3 M1_conM11M12
X$14 \$3 \$9 \$1 \$I300 nmos$3
X$15 \$1 \$9 M1_conM11M12
X$16 \$9 \$20 \$1 \$I305 nmos$3
X$17 \$1 \$20 M1_conM11M12
X$18 \$20 \$16 \$1 \$I310 nmos$3
X$19 \$1 \$16 M1_conM11M12
X$20 \$16 \$8 \$1 \$I315 nmos$3
X$21 \$1 \$8 M1_conM11M12
X$22 \$8 \$6 \$1 \$I320 nmos$3
X$23 \$1 \$6 M1_conM11M12
X$24 \$21 \$4 \$1 \$I271 nmos$3
X$25 \$1 \$21 M1_conM11M12
X$26 \$1 \$4 M1_conM11M12
X$27 \$4 \$34 \$1 \$I275 nmos$3
X$28 \$1 \$34 M1_conM11M12
X$29 \$34 \$2 \$1 \$I280 nmos$3
X$30 \$1 \$2 M1_conM11M12
X$31 \$2 \$10 \$1 \$I285 nmos$3
X$32 \$1 \$10 M1_conM11M12
X$33 \$10 \$7 \$1 \$I290 nmos$3
X$34 \$1 \$7 M1_conM11M12
X$35 \$7 \$3 \$1 \$I295 nmos$3
X$36 \$1 \$3 M1_conM11M12
X$37 \$3 \$9 \$1 \$I300 nmos$3
X$38 \$1 \$9 M1_conM11M12
X$39 \$9 \$20 \$1 \$I305 nmos$3
X$40 \$1 \$20 M1_conM11M12
X$41 \$20 \$16 \$1 \$I310 nmos$3
X$42 \$1 \$16 M1_conM11M12
X$43 \$16 \$8 \$1 \$I315 nmos$3
X$44 \$1 \$8 M1_conM11M12
X$45 \$8 \$6 \$1 \$I320 nmos$3
X$46 \$1 \$6 M1_conM11M12
X$47 \$21 \$4 \$1 \$I271 nmos$3
X$48 \$1 \$21 M1_conM11M12
X$49 \$1 \$4 M1_conM11M12
X$50 \$4 \$34 \$1 \$I275 nmos$3
X$51 \$1 \$34 M1_conM11M12
X$52 \$34 \$2 \$1 \$I280 nmos$3
X$53 \$1 \$2 M1_conM11M12
X$54 \$2 \$10 \$1 \$I285 nmos$3
X$55 \$1 \$10 M1_conM11M12
X$56 \$10 \$7 \$1 \$I290 nmos$3
X$57 \$1 \$7 M1_conM11M12
X$58 \$7 \$3 \$1 \$I295 nmos$3
X$59 \$1 \$3 M1_conM11M12
X$60 \$3 \$9 \$1 \$I300 nmos$3
X$61 \$1 \$9 M1_conM11M12
X$62 \$9 \$20 \$1 \$I305 nmos$3
X$63 \$1 \$20 M1_conM11M12
X$64 \$20 \$16 \$1 \$I310 nmos$3
X$65 \$1 \$16 M1_conM11M12
X$66 \$16 \$8 \$1 \$I315 nmos$3
X$67 \$1 \$8 M1_conM11M12
X$68 \$8 \$6 \$1 \$I320 nmos$3
X$69 \$1 \$6 M1_conM11M12
X$70 \$21 \$4 \$1 \$I271 nmos$3
X$71 \$1 \$21 M1_conM11M12
X$72 \$1 \$4 M1_conM11M12
X$73 \$4 \$34 \$1 \$I275 nmos$3
X$74 \$1 \$34 M1_conM11M12
X$75 \$34 \$2 \$1 \$I280 nmos$3
X$76 \$1 \$2 M1_conM11M12
X$77 \$2 \$10 \$1 \$I285 nmos$3
X$78 \$1 \$10 M1_conM11M12
X$79 \$10 \$7 \$1 \$I290 nmos$3
X$80 \$1 \$7 M1_conM11M12
X$81 \$7 \$3 \$1 \$I295 nmos$3
X$82 \$1 \$3 M1_conM11M12
X$83 \$3 \$9 \$1 \$I300 nmos$3
X$84 \$1 \$9 M1_conM11M12
X$85 \$9 \$20 \$1 \$I305 nmos$3
X$86 \$1 \$20 M1_conM11M12
X$87 \$20 \$16 \$1 \$I310 nmos$3
X$88 \$1 \$16 M1_conM11M12
X$89 \$16 \$8 \$1 \$I315 nmos$3
X$90 \$1 \$8 M1_conM11M12
X$91 \$8 \$6 \$1 \$I320 nmos$3
X$92 \$1 \$6 M1_conM11M12
X$93 \$21 \$4 \$1 \$I271 nmos$3
X$94 \$4 \$34 \$1 \$I275 nmos$3
X$95 \$34 \$2 \$1 \$I280 nmos$3
X$96 \$2 \$10 \$1 \$I285 nmos$3
X$97 \$10 \$7 \$1 \$I290 nmos$3
X$98 \$7 \$3 \$1 \$I295 nmos$3
X$99 \$3 \$9 \$1 \$I300 nmos$3
X$100 \$9 \$20 \$1 \$I305 nmos$3
X$101 \$20 \$16 \$1 \$I310 nmos$3
X$102 \$16 \$8 \$1 \$I315 nmos$3
X$103 \$8 \$6 \$1 \$I320 nmos$3
M$1 \$21 \$I271 \$4 \$1 sg13_lv_nmos L=1.06u W=4.8u AS=1.632p AD=0.912p
+ PS=10.28u PD=5.18u
M$2 \$4 \$I275 \$34 \$1 sg13_lv_nmos L=1.06u W=4.8u AS=0.912p AD=0.912p
+ PS=5.18u PD=5.18u
M$3 \$34 \$I280 \$2 \$1 sg13_lv_nmos L=1.06u W=4.8u AS=0.912p AD=0.912p
+ PS=5.18u PD=5.18u
M$4 \$2 \$I285 \$10 \$1 sg13_lv_nmos L=1.06u W=4.8u AS=0.912p AD=0.912p
+ PS=5.18u PD=5.18u
M$5 \$10 \$I290 \$7 \$1 sg13_lv_nmos L=1.06u W=4.8u AS=0.912p AD=0.912p
+ PS=5.18u PD=5.18u
M$6 \$7 \$I295 \$3 \$1 sg13_lv_nmos L=1.06u W=4.8u AS=0.912p AD=0.912p PS=5.18u
+ PD=5.18u
M$7 \$3 \$I300 \$9 \$1 sg13_lv_nmos L=1.06u W=4.8u AS=0.912p AD=0.912p PS=5.18u
+ PD=5.18u
M$8 \$9 \$I305 \$20 \$1 sg13_lv_nmos L=1.06u W=4.8u AS=0.912p AD=0.912p
+ PS=5.18u PD=5.18u
M$9 \$20 \$I310 \$16 \$1 sg13_lv_nmos L=1.06u W=4.8u AS=0.912p AD=0.912p
+ PS=5.18u PD=5.18u
M$10 \$16 \$I315 \$8 \$1 sg13_lv_nmos L=1.06u W=4.8u AS=0.912p AD=0.912p
+ PS=5.18u PD=5.18u
M$11 \$8 \$I320 \$6 \$1 sg13_lv_nmos L=1.06u W=4.8u AS=0.912p AD=1.632p
+ PS=5.18u PD=10.28u
M$12 \$21 \$I271 \$4 \$1 sg13_lv_nmos L=1.06u W=4.8u AS=1.632p AD=0.912p
+ PS=10.28u PD=5.18u
M$13 \$4 \$I275 \$34 \$1 sg13_lv_nmos L=1.06u W=4.8u AS=0.912p AD=0.912p
+ PS=5.18u PD=5.18u
M$14 \$34 \$I280 \$2 \$1 sg13_lv_nmos L=1.06u W=4.8u AS=0.912p AD=0.912p
+ PS=5.18u PD=5.18u
M$15 \$2 \$I285 \$10 \$1 sg13_lv_nmos L=1.06u W=4.8u AS=0.912p AD=0.912p
+ PS=5.18u PD=5.18u
M$16 \$10 \$I290 \$7 \$1 sg13_lv_nmos L=1.06u W=4.8u AS=0.912p AD=0.912p
+ PS=5.18u PD=5.18u
M$17 \$7 \$I295 \$3 \$1 sg13_lv_nmos L=1.06u W=4.8u AS=0.912p AD=0.912p
+ PS=5.18u PD=5.18u
M$18 \$3 \$I300 \$9 \$1 sg13_lv_nmos L=1.06u W=4.8u AS=0.912p AD=0.912p
+ PS=5.18u PD=5.18u
M$19 \$9 \$I305 \$20 \$1 sg13_lv_nmos L=1.06u W=4.8u AS=0.912p AD=0.912p
+ PS=5.18u PD=5.18u
M$20 \$20 \$I310 \$16 \$1 sg13_lv_nmos L=1.06u W=4.8u AS=0.912p AD=0.912p
+ PS=5.18u PD=5.18u
M$21 \$16 \$I315 \$8 \$1 sg13_lv_nmos L=1.06u W=4.8u AS=0.912p AD=0.912p
+ PS=5.18u PD=5.18u
M$22 \$8 \$I320 \$6 \$1 sg13_lv_nmos L=1.06u W=4.8u AS=0.912p AD=1.632p
+ PS=5.18u PD=10.28u
M$23 \$21 \$I271 \$4 \$1 sg13_lv_nmos L=1.06u W=4.8u AS=1.632p AD=0.912p
+ PS=10.28u PD=5.18u
M$24 \$4 \$I275 \$34 \$1 sg13_lv_nmos L=1.06u W=4.8u AS=0.912p AD=0.912p
+ PS=5.18u PD=5.18u
M$25 \$34 \$I280 \$2 \$1 sg13_lv_nmos L=1.06u W=4.8u AS=0.912p AD=0.912p
+ PS=5.18u PD=5.18u
M$26 \$2 \$I285 \$10 \$1 sg13_lv_nmos L=1.06u W=4.8u AS=0.912p AD=0.912p
+ PS=5.18u PD=5.18u
M$27 \$10 \$I290 \$7 \$1 sg13_lv_nmos L=1.06u W=4.8u AS=0.912p AD=0.912p
+ PS=5.18u PD=5.18u
M$28 \$7 \$I295 \$3 \$1 sg13_lv_nmos L=1.06u W=4.8u AS=0.912p AD=0.912p
+ PS=5.18u PD=5.18u
M$29 \$3 \$I300 \$9 \$1 sg13_lv_nmos L=1.06u W=4.8u AS=0.912p AD=0.912p
+ PS=5.18u PD=5.18u
M$30 \$9 \$I305 \$20 \$1 sg13_lv_nmos L=1.06u W=4.8u AS=0.912p AD=0.912p
+ PS=5.18u PD=5.18u
M$31 \$20 \$I310 \$16 \$1 sg13_lv_nmos L=1.06u W=4.8u AS=0.912p AD=0.912p
+ PS=5.18u PD=5.18u
M$32 \$16 \$I315 \$8 \$1 sg13_lv_nmos L=1.06u W=4.8u AS=0.912p AD=0.912p
+ PS=5.18u PD=5.18u
M$33 \$8 \$I320 \$6 \$1 sg13_lv_nmos L=1.06u W=4.8u AS=0.912p AD=1.632p
+ PS=5.18u PD=10.28u
M$34 \$21 \$I271 \$4 \$1 sg13_lv_nmos L=1.06u W=4.8u AS=1.632p AD=0.912p
+ PS=10.28u PD=5.18u
M$35 \$4 \$I275 \$34 \$1 sg13_lv_nmos L=1.06u W=4.8u AS=0.912p AD=0.912p
+ PS=5.18u PD=5.18u
M$36 \$34 \$I280 \$2 \$1 sg13_lv_nmos L=1.06u W=4.8u AS=0.912p AD=0.912p
+ PS=5.18u PD=5.18u
M$37 \$2 \$I285 \$10 \$1 sg13_lv_nmos L=1.06u W=4.8u AS=0.912p AD=0.912p
+ PS=5.18u PD=5.18u
M$38 \$10 \$I290 \$7 \$1 sg13_lv_nmos L=1.06u W=4.8u AS=0.912p AD=0.912p
+ PS=5.18u PD=5.18u
M$39 \$7 \$I295 \$3 \$1 sg13_lv_nmos L=1.06u W=4.8u AS=0.912p AD=0.912p
+ PS=5.18u PD=5.18u
M$40 \$3 \$I300 \$9 \$1 sg13_lv_nmos L=1.06u W=4.8u AS=0.912p AD=0.912p
+ PS=5.18u PD=5.18u
M$41 \$9 \$I305 \$20 \$1 sg13_lv_nmos L=1.06u W=4.8u AS=0.912p AD=0.912p
+ PS=5.18u PD=5.18u
M$42 \$20 \$I310 \$16 \$1 sg13_lv_nmos L=1.06u W=4.8u AS=0.912p AD=0.912p
+ PS=5.18u PD=5.18u
M$43 \$16 \$I315 \$8 \$1 sg13_lv_nmos L=1.06u W=4.8u AS=0.912p AD=0.912p
+ PS=5.18u PD=5.18u
M$44 \$8 \$I320 \$6 \$1 sg13_lv_nmos L=1.06u W=4.8u AS=0.912p AD=1.632p
+ PS=5.18u PD=10.28u
M$45 \$21 \$I271 \$4 \$1 sg13_lv_nmos L=1.06u W=4.8u AS=1.632p AD=0.912p
+ PS=10.28u PD=5.18u
M$46 \$4 \$I275 \$34 \$1 sg13_lv_nmos L=1.06u W=4.8u AS=0.912p AD=0.912p
+ PS=5.18u PD=5.18u
M$47 \$34 \$I280 \$2 \$1 sg13_lv_nmos L=1.06u W=4.8u AS=0.912p AD=0.912p
+ PS=5.18u PD=5.18u
M$48 \$2 \$I285 \$10 \$1 sg13_lv_nmos L=1.06u W=4.8u AS=0.912p AD=0.912p
+ PS=5.18u PD=5.18u
M$49 \$10 \$I290 \$7 \$1 sg13_lv_nmos L=1.06u W=4.8u AS=0.912p AD=0.912p
+ PS=5.18u PD=5.18u
M$50 \$7 \$I295 \$3 \$1 sg13_lv_nmos L=1.06u W=4.8u AS=0.912p AD=0.912p
+ PS=5.18u PD=5.18u
M$51 \$3 \$I300 \$9 \$1 sg13_lv_nmos L=1.06u W=4.8u AS=0.912p AD=0.912p
+ PS=5.18u PD=5.18u
M$52 \$9 \$I305 \$20 \$1 sg13_lv_nmos L=1.06u W=4.8u AS=0.912p AD=0.912p
+ PS=5.18u PD=5.18u
M$53 \$20 \$I310 \$16 \$1 sg13_lv_nmos L=1.06u W=4.8u AS=0.912p AD=0.912p
+ PS=5.18u PD=5.18u
M$54 \$16 \$I315 \$8 \$1 sg13_lv_nmos L=1.06u W=4.8u AS=0.912p AD=0.912p
+ PS=5.18u PD=5.18u
M$55 \$8 \$I320 \$6 \$1 sg13_lv_nmos L=1.06u W=4.8u AS=0.912p AD=1.632p
+ PS=5.18u PD=10.28u
.ENDS M11M12

.SUBCKT gateM11M12$1 \$1 \$2
X$1 \$2 \$1 via_stack$6
.ENDS gateM11M12$1

.SUBCKT sourceM11M12$1 \$1 \$2
X$1 \$1 \$2 sourceRowM11M12$1
X$2 \$1 \$2 topRow$1
X$3 \$1 \$2 sourceRowM11M12$1
.ENDS sourceM11M12$1

.SUBCKT drainM11M12$1 \$1 \$2
X$1 \$1 \$2 drainRowM11M12$1
X$2 \$1 \$2 drainRowM11M12$1
X$3 \$1 \$2 topRow$1
.ENDS drainM11M12$1

.SUBCKT M11M12$1 \$1 \$2 \$3 \$4 \$6 \$7 \$8 \$9 \$10 \$16 \$20 \$21 \$34
+ \$I231 \$I226 \$I221 \$I216 \$I211 \$I206 \$I201 \$I196 \$I191 \$I186 \$I181
X$1 \$21 \$4 \$1 \$I181 nmos$3
X$2 \$1 \$21 M1_conM11M12$1
X$3 \$1 \$4 M1_conM11M12$1
X$4 \$4 \$34 \$1 \$I186 nmos$3
X$5 \$1 \$34 M1_conM11M12$1
X$6 \$34 \$2 \$1 \$I191 nmos$3
X$7 \$1 \$2 M1_conM11M12$1
X$8 \$2 \$10 \$1 \$I196 nmos$3
X$9 \$1 \$10 M1_conM11M12$1
X$10 \$10 \$7 \$1 \$I201 nmos$3
X$11 \$1 \$7 M1_conM11M12$1
X$12 \$7 \$3 \$1 \$I206 nmos$3
X$13 \$1 \$3 M1_conM11M12$1
X$14 \$3 \$9 \$1 \$I211 nmos$3
X$15 \$1 \$9 M1_conM11M12$1
X$16 \$9 \$20 \$1 \$I216 nmos$3
X$17 \$1 \$20 M1_conM11M12$1
X$18 \$20 \$16 \$1 \$I221 nmos$3
X$19 \$1 \$16 M1_conM11M12$1
X$20 \$16 \$8 \$1 \$I226 nmos$3
X$21 \$1 \$8 M1_conM11M12$1
X$22 \$8 \$6 \$1 \$I231 nmos$3
X$23 \$1 \$6 M1_conM11M12$1
X$24 \$21 \$4 \$1 \$I181 nmos$3
X$25 \$1 \$21 M1_conM11M12$1
X$26 \$1 \$4 M1_conM11M12$1
X$27 \$4 \$34 \$1 \$I186 nmos$3
X$28 \$1 \$34 M1_conM11M12$1
X$29 \$34 \$2 \$1 \$I191 nmos$3
X$30 \$1 \$2 M1_conM11M12$1
X$31 \$2 \$10 \$1 \$I196 nmos$3
X$32 \$1 \$10 M1_conM11M12$1
X$33 \$10 \$7 \$1 \$I201 nmos$3
X$34 \$1 \$7 M1_conM11M12$1
X$35 \$7 \$3 \$1 \$I206 nmos$3
X$36 \$1 \$3 M1_conM11M12$1
X$37 \$3 \$9 \$1 \$I211 nmos$3
X$38 \$1 \$9 M1_conM11M12$1
X$39 \$9 \$20 \$1 \$I216 nmos$3
X$40 \$1 \$20 M1_conM11M12$1
X$41 \$20 \$16 \$1 \$I221 nmos$3
X$42 \$1 \$16 M1_conM11M12$1
X$43 \$16 \$8 \$1 \$I226 nmos$3
X$44 \$1 \$8 M1_conM11M12$1
X$45 \$8 \$6 \$1 \$I231 nmos$3
X$46 \$1 \$6 M1_conM11M12$1
X$47 \$21 \$4 \$1 \$I181 nmos$3
X$48 \$1 \$21 M1_conM11M12$1
X$49 \$1 \$4 M1_conM11M12$1
X$50 \$4 \$34 \$1 \$I186 nmos$3
X$51 \$1 \$34 M1_conM11M12$1
X$52 \$34 \$2 \$1 \$I191 nmos$3
X$53 \$1 \$2 M1_conM11M12$1
X$54 \$2 \$10 \$1 \$I196 nmos$3
X$55 \$1 \$10 M1_conM11M12$1
X$56 \$10 \$7 \$1 \$I201 nmos$3
X$57 \$1 \$7 M1_conM11M12$1
X$58 \$7 \$3 \$1 \$I206 nmos$3
X$59 \$1 \$3 M1_conM11M12$1
X$60 \$3 \$9 \$1 \$I211 nmos$3
X$61 \$1 \$9 M1_conM11M12$1
X$62 \$9 \$20 \$1 \$I216 nmos$3
X$63 \$1 \$20 M1_conM11M12$1
X$64 \$20 \$16 \$1 \$I221 nmos$3
X$65 \$1 \$16 M1_conM11M12$1
X$66 \$16 \$8 \$1 \$I226 nmos$3
X$67 \$1 \$8 M1_conM11M12$1
X$68 \$8 \$6 \$1 \$I231 nmos$3
X$69 \$1 \$6 M1_conM11M12$1
X$70 \$21 \$4 \$1 \$I181 nmos$3
X$71 \$1 \$21 M1_conM11M12$1
X$72 \$1 \$4 M1_conM11M12$1
X$73 \$4 \$34 \$1 \$I186 nmos$3
X$74 \$1 \$34 M1_conM11M12$1
X$75 \$34 \$2 \$1 \$I191 nmos$3
X$76 \$1 \$2 M1_conM11M12$1
X$77 \$2 \$10 \$1 \$I196 nmos$3
X$78 \$1 \$10 M1_conM11M12$1
X$79 \$10 \$7 \$1 \$I201 nmos$3
X$80 \$1 \$7 M1_conM11M12$1
X$81 \$7 \$3 \$1 \$I206 nmos$3
X$82 \$1 \$3 M1_conM11M12$1
X$83 \$3 \$9 \$1 \$I211 nmos$3
X$84 \$1 \$9 M1_conM11M12$1
X$85 \$9 \$20 \$1 \$I216 nmos$3
X$86 \$1 \$20 M1_conM11M12$1
X$87 \$20 \$16 \$1 \$I221 nmos$3
X$88 \$1 \$16 M1_conM11M12$1
X$89 \$16 \$8 \$1 \$I226 nmos$3
X$90 \$1 \$8 M1_conM11M12$1
X$91 \$8 \$6 \$1 \$I231 nmos$3
X$92 \$1 \$6 M1_conM11M12$1
X$93 \$21 \$4 \$1 \$I181 nmos$3
X$94 \$4 \$34 \$1 \$I186 nmos$3
X$95 \$34 \$2 \$1 \$I191 nmos$3
X$96 \$2 \$10 \$1 \$I196 nmos$3
X$97 \$10 \$7 \$1 \$I201 nmos$3
X$98 \$7 \$3 \$1 \$I206 nmos$3
X$99 \$3 \$9 \$1 \$I211 nmos$3
X$100 \$9 \$20 \$1 \$I216 nmos$3
X$101 \$20 \$16 \$1 \$I221 nmos$3
X$102 \$16 \$8 \$1 \$I226 nmos$3
X$103 \$8 \$6 \$1 \$I231 nmos$3
M$1 \$21 \$I181 \$4 \$1 sg13_lv_nmos L=1.06u W=4.8u AS=1.632p AD=0.912p
+ PS=10.28u PD=5.18u
M$2 \$4 \$I186 \$34 \$1 sg13_lv_nmos L=1.06u W=4.8u AS=0.912p AD=0.912p
+ PS=5.18u PD=5.18u
M$3 \$34 \$I191 \$2 \$1 sg13_lv_nmos L=1.06u W=4.8u AS=0.912p AD=0.912p
+ PS=5.18u PD=5.18u
M$4 \$2 \$I196 \$10 \$1 sg13_lv_nmos L=1.06u W=4.8u AS=0.912p AD=0.912p
+ PS=5.18u PD=5.18u
M$5 \$10 \$I201 \$7 \$1 sg13_lv_nmos L=1.06u W=4.8u AS=0.912p AD=0.912p
+ PS=5.18u PD=5.18u
M$6 \$7 \$I206 \$3 \$1 sg13_lv_nmos L=1.06u W=4.8u AS=0.912p AD=0.912p PS=5.18u
+ PD=5.18u
M$7 \$3 \$I211 \$9 \$1 sg13_lv_nmos L=1.06u W=4.8u AS=0.912p AD=0.912p PS=5.18u
+ PD=5.18u
M$8 \$9 \$I216 \$20 \$1 sg13_lv_nmos L=1.06u W=4.8u AS=0.912p AD=0.912p
+ PS=5.18u PD=5.18u
M$9 \$20 \$I221 \$16 \$1 sg13_lv_nmos L=1.06u W=4.8u AS=0.912p AD=0.912p
+ PS=5.18u PD=5.18u
M$10 \$16 \$I226 \$8 \$1 sg13_lv_nmos L=1.06u W=4.8u AS=0.912p AD=0.912p
+ PS=5.18u PD=5.18u
M$11 \$8 \$I231 \$6 \$1 sg13_lv_nmos L=1.06u W=4.8u AS=0.912p AD=1.632p
+ PS=5.18u PD=10.28u
M$12 \$21 \$I181 \$4 \$1 sg13_lv_nmos L=1.06u W=4.8u AS=1.632p AD=0.912p
+ PS=10.28u PD=5.18u
M$13 \$4 \$I186 \$34 \$1 sg13_lv_nmos L=1.06u W=4.8u AS=0.912p AD=0.912p
+ PS=5.18u PD=5.18u
M$14 \$34 \$I191 \$2 \$1 sg13_lv_nmos L=1.06u W=4.8u AS=0.912p AD=0.912p
+ PS=5.18u PD=5.18u
M$15 \$2 \$I196 \$10 \$1 sg13_lv_nmos L=1.06u W=4.8u AS=0.912p AD=0.912p
+ PS=5.18u PD=5.18u
M$16 \$10 \$I201 \$7 \$1 sg13_lv_nmos L=1.06u W=4.8u AS=0.912p AD=0.912p
+ PS=5.18u PD=5.18u
M$17 \$7 \$I206 \$3 \$1 sg13_lv_nmos L=1.06u W=4.8u AS=0.912p AD=0.912p
+ PS=5.18u PD=5.18u
M$18 \$3 \$I211 \$9 \$1 sg13_lv_nmos L=1.06u W=4.8u AS=0.912p AD=0.912p
+ PS=5.18u PD=5.18u
M$19 \$9 \$I216 \$20 \$1 sg13_lv_nmos L=1.06u W=4.8u AS=0.912p AD=0.912p
+ PS=5.18u PD=5.18u
M$20 \$20 \$I221 \$16 \$1 sg13_lv_nmos L=1.06u W=4.8u AS=0.912p AD=0.912p
+ PS=5.18u PD=5.18u
M$21 \$16 \$I226 \$8 \$1 sg13_lv_nmos L=1.06u W=4.8u AS=0.912p AD=0.912p
+ PS=5.18u PD=5.18u
M$22 \$8 \$I231 \$6 \$1 sg13_lv_nmos L=1.06u W=4.8u AS=0.912p AD=1.632p
+ PS=5.18u PD=10.28u
M$23 \$21 \$I181 \$4 \$1 sg13_lv_nmos L=1.06u W=4.8u AS=1.632p AD=0.912p
+ PS=10.28u PD=5.18u
M$24 \$4 \$I186 \$34 \$1 sg13_lv_nmos L=1.06u W=4.8u AS=0.912p AD=0.912p
+ PS=5.18u PD=5.18u
M$25 \$34 \$I191 \$2 \$1 sg13_lv_nmos L=1.06u W=4.8u AS=0.912p AD=0.912p
+ PS=5.18u PD=5.18u
M$26 \$2 \$I196 \$10 \$1 sg13_lv_nmos L=1.06u W=4.8u AS=0.912p AD=0.912p
+ PS=5.18u PD=5.18u
M$27 \$10 \$I201 \$7 \$1 sg13_lv_nmos L=1.06u W=4.8u AS=0.912p AD=0.912p
+ PS=5.18u PD=5.18u
M$28 \$7 \$I206 \$3 \$1 sg13_lv_nmos L=1.06u W=4.8u AS=0.912p AD=0.912p
+ PS=5.18u PD=5.18u
M$29 \$3 \$I211 \$9 \$1 sg13_lv_nmos L=1.06u W=4.8u AS=0.912p AD=0.912p
+ PS=5.18u PD=5.18u
M$30 \$9 \$I216 \$20 \$1 sg13_lv_nmos L=1.06u W=4.8u AS=0.912p AD=0.912p
+ PS=5.18u PD=5.18u
M$31 \$20 \$I221 \$16 \$1 sg13_lv_nmos L=1.06u W=4.8u AS=0.912p AD=0.912p
+ PS=5.18u PD=5.18u
M$32 \$16 \$I226 \$8 \$1 sg13_lv_nmos L=1.06u W=4.8u AS=0.912p AD=0.912p
+ PS=5.18u PD=5.18u
M$33 \$8 \$I231 \$6 \$1 sg13_lv_nmos L=1.06u W=4.8u AS=0.912p AD=1.632p
+ PS=5.18u PD=10.28u
M$34 \$21 \$I181 \$4 \$1 sg13_lv_nmos L=1.06u W=4.8u AS=1.632p AD=0.912p
+ PS=10.28u PD=5.18u
M$35 \$4 \$I186 \$34 \$1 sg13_lv_nmos L=1.06u W=4.8u AS=0.912p AD=0.912p
+ PS=5.18u PD=5.18u
M$36 \$34 \$I191 \$2 \$1 sg13_lv_nmos L=1.06u W=4.8u AS=0.912p AD=0.912p
+ PS=5.18u PD=5.18u
M$37 \$2 \$I196 \$10 \$1 sg13_lv_nmos L=1.06u W=4.8u AS=0.912p AD=0.912p
+ PS=5.18u PD=5.18u
M$38 \$10 \$I201 \$7 \$1 sg13_lv_nmos L=1.06u W=4.8u AS=0.912p AD=0.912p
+ PS=5.18u PD=5.18u
M$39 \$7 \$I206 \$3 \$1 sg13_lv_nmos L=1.06u W=4.8u AS=0.912p AD=0.912p
+ PS=5.18u PD=5.18u
M$40 \$3 \$I211 \$9 \$1 sg13_lv_nmos L=1.06u W=4.8u AS=0.912p AD=0.912p
+ PS=5.18u PD=5.18u
M$41 \$9 \$I216 \$20 \$1 sg13_lv_nmos L=1.06u W=4.8u AS=0.912p AD=0.912p
+ PS=5.18u PD=5.18u
M$42 \$20 \$I221 \$16 \$1 sg13_lv_nmos L=1.06u W=4.8u AS=0.912p AD=0.912p
+ PS=5.18u PD=5.18u
M$43 \$16 \$I226 \$8 \$1 sg13_lv_nmos L=1.06u W=4.8u AS=0.912p AD=0.912p
+ PS=5.18u PD=5.18u
M$44 \$8 \$I231 \$6 \$1 sg13_lv_nmos L=1.06u W=4.8u AS=0.912p AD=1.632p
+ PS=5.18u PD=10.28u
M$45 \$21 \$I181 \$4 \$1 sg13_lv_nmos L=1.06u W=4.8u AS=1.632p AD=0.912p
+ PS=10.28u PD=5.18u
M$46 \$4 \$I186 \$34 \$1 sg13_lv_nmos L=1.06u W=4.8u AS=0.912p AD=0.912p
+ PS=5.18u PD=5.18u
M$47 \$34 \$I191 \$2 \$1 sg13_lv_nmos L=1.06u W=4.8u AS=0.912p AD=0.912p
+ PS=5.18u PD=5.18u
M$48 \$2 \$I196 \$10 \$1 sg13_lv_nmos L=1.06u W=4.8u AS=0.912p AD=0.912p
+ PS=5.18u PD=5.18u
M$49 \$10 \$I201 \$7 \$1 sg13_lv_nmos L=1.06u W=4.8u AS=0.912p AD=0.912p
+ PS=5.18u PD=5.18u
M$50 \$7 \$I206 \$3 \$1 sg13_lv_nmos L=1.06u W=4.8u AS=0.912p AD=0.912p
+ PS=5.18u PD=5.18u
M$51 \$3 \$I211 \$9 \$1 sg13_lv_nmos L=1.06u W=4.8u AS=0.912p AD=0.912p
+ PS=5.18u PD=5.18u
M$52 \$9 \$I216 \$20 \$1 sg13_lv_nmos L=1.06u W=4.8u AS=0.912p AD=0.912p
+ PS=5.18u PD=5.18u
M$53 \$20 \$I221 \$16 \$1 sg13_lv_nmos L=1.06u W=4.8u AS=0.912p AD=0.912p
+ PS=5.18u PD=5.18u
M$54 \$16 \$I226 \$8 \$1 sg13_lv_nmos L=1.06u W=4.8u AS=0.912p AD=0.912p
+ PS=5.18u PD=5.18u
M$55 \$8 \$I231 \$6 \$1 sg13_lv_nmos L=1.06u W=4.8u AS=0.912p AD=1.632p
+ PS=5.18u PD=10.28u
.ENDS M11M12$1

.SUBCKT sourceRowM3M4$1 \$1 \$2
X$1 \$2 \$1 via_stack
X$2 \$2 \$1 via_stack
X$3 \$2 \$1 via_stack
X$4 \$2 \$1 via_stack
.ENDS sourceRowM3M4$1

.SUBCKT topRowM3M4$1 \$1 \$2
X$1 \$2 \$1 via_stack$1
X$2 \$2 \$1 via_stack$1
X$3 \$2 \$1 via_stack$1
.ENDS topRowM3M4$1

.SUBCKT gateM3M4$1 \$1 \$2
X$1 \$2 \$1 via_stack$7
.ENDS gateM3M4$1

.SUBCKT drainRowM3M4$1 \$1 \$2
X$1 \$2 \$1 via_stack$1
X$2 \$2 \$1 via_stack$1
X$3 \$2 \$1 via_stack$1
.ENDS drainRowM3M4$1

.SUBCKT M3M4$1 \$1 \$2 \$3 \$4 \$5 \$6 \$11 \$12 \$I180 \$I175 \$I170 \$I165
+ \$I160 \$I156
X$1 \$12 \$3 \$1 \$I156 nmos$2
X$2 \$1 \$12 M1_conM3M4$1
X$3 \$1 \$3 M1_conM3M4$1
X$4 \$3 \$4 \$1 \$I160 nmos$2
X$5 \$1 \$4 M1_conM3M4$1
X$6 \$4 \$2 \$1 \$I165 nmos$2
X$7 \$1 \$2 M1_conM3M4$1
X$8 \$2 \$6 \$1 \$I170 nmos$2
X$9 \$1 \$6 M1_conM3M4$1
X$10 \$6 \$5 \$1 \$I175 nmos$2
X$11 \$1 \$5 M1_conM3M4$1
X$12 \$5 \$11 \$1 \$I180 nmos$2
X$13 \$1 \$11 M1_conM3M4$1
X$14 \$12 \$3 \$1 \$I156 nmos$2
X$15 \$1 \$12 M1_conM3M4$1
X$16 \$1 \$3 M1_conM3M4$1
X$17 \$3 \$4 \$1 \$I160 nmos$2
X$18 \$1 \$4 M1_conM3M4$1
X$19 \$4 \$2 \$1 \$I165 nmos$2
X$20 \$1 \$2 M1_conM3M4$1
X$21 \$2 \$6 \$1 \$I170 nmos$2
X$22 \$1 \$6 M1_conM3M4$1
X$23 \$6 \$5 \$1 \$I175 nmos$2
X$24 \$1 \$5 M1_conM3M4$1
X$25 \$5 \$11 \$1 \$I180 nmos$2
X$26 \$1 \$11 M1_conM3M4$1
X$27 \$12 \$3 \$1 \$I156 nmos$2
X$28 \$1 \$12 M1_conM3M4$1
X$29 \$1 \$3 M1_conM3M4$1
X$30 \$3 \$4 \$1 \$I160 nmos$2
X$31 \$1 \$4 M1_conM3M4$1
X$32 \$4 \$2 \$1 \$I165 nmos$2
X$33 \$1 \$2 M1_conM3M4$1
X$34 \$2 \$6 \$1 \$I170 nmos$2
X$35 \$1 \$6 M1_conM3M4$1
X$36 \$6 \$5 \$1 \$I175 nmos$2
X$37 \$1 \$5 M1_conM3M4$1
X$38 \$5 \$11 \$1 \$I180 nmos$2
X$39 \$1 \$11 M1_conM3M4$1
X$40 \$12 \$3 \$1 \$I156 nmos$2
X$41 \$1 \$12 M1_conM3M4$1
X$42 \$1 \$3 M1_conM3M4$1
X$43 \$3 \$4 \$1 \$I160 nmos$2
X$44 \$1 \$4 M1_conM3M4$1
X$45 \$4 \$2 \$1 \$I165 nmos$2
X$46 \$1 \$2 M1_conM3M4$1
X$47 \$2 \$6 \$1 \$I170 nmos$2
X$48 \$1 \$6 M1_conM3M4$1
X$49 \$6 \$5 \$1 \$I175 nmos$2
X$50 \$1 \$5 M1_conM3M4$1
X$51 \$5 \$11 \$1 \$I180 nmos$2
X$52 \$1 \$11 M1_conM3M4$1
X$53 \$12 \$3 \$1 \$I156 nmos$2
X$54 \$3 \$4 \$1 \$I160 nmos$2
X$55 \$4 \$2 \$1 \$I165 nmos$2
X$56 \$2 \$6 \$1 \$I170 nmos$2
X$57 \$6 \$5 \$1 \$I175 nmos$2
X$58 \$5 \$11 \$1 \$I180 nmos$2
M$1 \$12 \$I156 \$3 \$1 sg13_lv_nmos L=0.16u W=1.9u AS=0.646p AD=0.361p
+ PS=4.48u PD=2.28u
M$2 \$3 \$I160 \$4 \$1 sg13_lv_nmos L=0.16u W=1.9u AS=0.361p AD=0.361p PS=2.28u
+ PD=2.28u
M$3 \$4 \$I165 \$2 \$1 sg13_lv_nmos L=0.16u W=1.9u AS=0.361p AD=0.361p PS=2.28u
+ PD=2.28u
M$4 \$2 \$I170 \$6 \$1 sg13_lv_nmos L=0.16u W=1.9u AS=0.361p AD=0.361p PS=2.28u
+ PD=2.28u
M$5 \$6 \$I175 \$5 \$1 sg13_lv_nmos L=0.16u W=1.9u AS=0.361p AD=0.361p PS=2.28u
+ PD=2.28u
M$6 \$5 \$I180 \$11 \$1 sg13_lv_nmos L=0.16u W=1.9u AS=0.361p AD=0.646p
+ PS=2.28u PD=4.48u
M$7 \$12 \$I156 \$3 \$1 sg13_lv_nmos L=0.16u W=1.9u AS=0.646p AD=0.361p
+ PS=4.48u PD=2.28u
M$8 \$3 \$I160 \$4 \$1 sg13_lv_nmos L=0.16u W=1.9u AS=0.361p AD=0.361p PS=2.28u
+ PD=2.28u
M$9 \$4 \$I165 \$2 \$1 sg13_lv_nmos L=0.16u W=1.9u AS=0.361p AD=0.361p PS=2.28u
+ PD=2.28u
M$10 \$2 \$I170 \$6 \$1 sg13_lv_nmos L=0.16u W=1.9u AS=0.361p AD=0.361p
+ PS=2.28u PD=2.28u
M$11 \$6 \$I175 \$5 \$1 sg13_lv_nmos L=0.16u W=1.9u AS=0.361p AD=0.361p
+ PS=2.28u PD=2.28u
M$12 \$5 \$I180 \$11 \$1 sg13_lv_nmos L=0.16u W=1.9u AS=0.361p AD=0.646p
+ PS=2.28u PD=4.48u
M$13 \$12 \$I156 \$3 \$1 sg13_lv_nmos L=0.16u W=1.9u AS=0.646p AD=0.361p
+ PS=4.48u PD=2.28u
M$14 \$3 \$I160 \$4 \$1 sg13_lv_nmos L=0.16u W=1.9u AS=0.361p AD=0.361p
+ PS=2.28u PD=2.28u
M$15 \$4 \$I165 \$2 \$1 sg13_lv_nmos L=0.16u W=1.9u AS=0.361p AD=0.361p
+ PS=2.28u PD=2.28u
M$16 \$2 \$I170 \$6 \$1 sg13_lv_nmos L=0.16u W=1.9u AS=0.361p AD=0.361p
+ PS=2.28u PD=2.28u
M$17 \$6 \$I175 \$5 \$1 sg13_lv_nmos L=0.16u W=1.9u AS=0.361p AD=0.361p
+ PS=2.28u PD=2.28u
M$18 \$5 \$I180 \$11 \$1 sg13_lv_nmos L=0.16u W=1.9u AS=0.361p AD=0.646p
+ PS=2.28u PD=4.48u
M$19 \$12 \$I156 \$3 \$1 sg13_lv_nmos L=0.16u W=1.9u AS=0.646p AD=0.361p
+ PS=4.48u PD=2.28u
M$20 \$3 \$I160 \$4 \$1 sg13_lv_nmos L=0.16u W=1.9u AS=0.361p AD=0.361p
+ PS=2.28u PD=2.28u
M$21 \$4 \$I165 \$2 \$1 sg13_lv_nmos L=0.16u W=1.9u AS=0.361p AD=0.361p
+ PS=2.28u PD=2.28u
M$22 \$2 \$I170 \$6 \$1 sg13_lv_nmos L=0.16u W=1.9u AS=0.361p AD=0.361p
+ PS=2.28u PD=2.28u
M$23 \$6 \$I175 \$5 \$1 sg13_lv_nmos L=0.16u W=1.9u AS=0.361p AD=0.361p
+ PS=2.28u PD=2.28u
M$24 \$5 \$I180 \$11 \$1 sg13_lv_nmos L=0.16u W=1.9u AS=0.361p AD=0.646p
+ PS=2.28u PD=4.48u
M$25 \$12 \$I156 \$3 \$1 sg13_lv_nmos L=0.16u W=1.9u AS=0.646p AD=0.361p
+ PS=4.48u PD=2.28u
M$26 \$3 \$I160 \$4 \$1 sg13_lv_nmos L=0.16u W=1.9u AS=0.361p AD=0.361p
+ PS=2.28u PD=2.28u
M$27 \$4 \$I165 \$2 \$1 sg13_lv_nmos L=0.16u W=1.9u AS=0.361p AD=0.361p
+ PS=2.28u PD=2.28u
M$28 \$2 \$I170 \$6 \$1 sg13_lv_nmos L=0.16u W=1.9u AS=0.361p AD=0.361p
+ PS=2.28u PD=2.28u
M$29 \$6 \$I175 \$5 \$1 sg13_lv_nmos L=0.16u W=1.9u AS=0.361p AD=0.361p
+ PS=2.28u PD=2.28u
M$30 \$5 \$I180 \$11 \$1 sg13_lv_nmos L=0.16u W=1.9u AS=0.361p AD=0.646p
+ PS=2.28u PD=4.48u
.ENDS M3M4$1

.SUBCKT M1_Cont1_NMOS$1 \$1
.ENDS M1_Cont1_NMOS$1

.SUBCKT M1_Cont1_PMOS$1 \$1 \$2
.ENDS M1_Cont1_PMOS$1

.SUBCKT gateM9M10$1 \$1 \$2
X$1 \$2 \$1 via_stack$11
.ENDS gateM9M10$1

.SUBCKT sourceM9M10$1 \$1 \$2
X$1 \$1 \$2 sourceRow$1
X$2 \$1 \$2 sourceRow$1
X$3 \$1 \$2 sourceRow$1
X$4 \$1 \$2 sourceRow$1
X$5 \$1 \$2 sourceRow$1
X$6 \$1 \$2 sourceRow$1
X$7 \$1 \$2 sourceRow$1
X$8 \$1 \$2 sourceRow$1
X$9 \$1 \$2 sourceRow$1
X$10 \$1 \$2 sourceRow$1
X$11 \$1 \$2 sourceRow$1
X$12 \$1 \$2 sourceRow$1
.ENDS sourceM9M10$1

.SUBCKT drainM9M10$1 \$1 \$2
X$1 \$1 \$2 drainRowM9M10$1
X$2 \$1 \$2 topRowM9M10$1
X$3 \$1 \$2 drainRowM9M10$1
X$4 \$1 \$2 drainRowM9M10$1
X$5 \$1 \$2 drainRowM9M10$1
X$6 \$1 \$2 drainRowM9M10$1
X$7 \$1 \$2 drainRowM9M10$1
X$8 \$1 \$2 drainRowM9M10$1
X$9 \$1 \$2 drainRowM9M10$1
X$10 \$1 \$2 drainRowM9M10$1
X$11 \$1 \$2 drainRowM9M10$1
X$12 \$1 \$2 drainRowM9M10$1
X$13 \$1 \$2 drainRowM9M10$1
.ENDS drainM9M10$1

.SUBCKT M9M10$1 \$1 \$2 \$3 \$7 \$8 \$9 \$13 \$14 \$15 \$19 \$20 \$267 \$I1764
+ \$I1763 \$I1762 \$I1744 \$I1743 \$I1697 \$I1695 \$I1095 \$I1070 \$I870 \$I274
X$1 \$1 \$9 \$I274 \$267 \$I870 pmos$1
X$2 \$2 \$1 \$I274 \$267 \$I1095 pmos$1
X$3 \$267 \$1 M1_conM9M10$1
X$4 \$1 \$9 \$I274 \$267 \$I870 pmos$1
X$5 \$2 \$1 \$I274 \$267 \$I1095 pmos$1
X$6 \$267 \$1 M1_conM9M10$1
X$7 \$1 \$9 \$I274 \$267 \$I870 pmos$1
X$8 \$2 \$1 \$I274 \$267 \$I1095 pmos$1
X$9 \$267 \$1 M1_conM9M10$1
X$10 \$1 \$9 \$I274 \$267 \$I870 pmos$1
X$11 \$2 \$1 \$I274 \$267 \$I1095 pmos$1
X$12 \$267 \$1 M1_conM9M10$1
X$13 \$1 \$9 \$I274 \$267 \$I870 pmos$1
X$14 \$2 \$1 \$I274 \$267 \$I1095 pmos$1
X$15 \$267 \$1 M1_conM9M10$1
X$16 \$1 \$9 \$I274 \$267 \$I870 pmos$1
X$17 \$2 \$1 \$I274 \$267 \$I1095 pmos$1
X$18 \$267 \$1 M1_conM9M10$1
X$19 \$1 \$9 \$I274 \$267 \$I870 pmos$1
X$20 \$2 \$1 \$I274 \$267 \$I1095 pmos$1
X$21 \$267 \$1 M1_conM9M10$1
X$22 \$1 \$9 \$I274 \$267 \$I870 pmos$1
X$23 \$2 \$1 \$I274 \$267 \$I1095 pmos$1
X$24 \$267 \$1 M1_conM9M10$1
X$25 \$1 \$9 \$I274 \$267 \$I870 pmos$1
X$26 \$2 \$1 \$I274 \$267 \$I1095 pmos$1
X$27 \$267 \$1 M1_conM9M10$1
X$28 \$1 \$9 \$I274 \$267 \$I870 pmos$1
X$29 \$2 \$1 \$I274 \$267 \$I1095 pmos$1
X$30 \$267 \$1 M1_conM9M10$1
X$31 \$1 \$9 \$I274 \$267 \$I870 pmos$1
X$32 \$2 \$1 \$I274 \$267 \$I1095 pmos$1
X$33 \$267 \$1 M1_conM9M10$1
X$34 \$1 \$9 \$I274 \$267 \$I870 pmos$1
X$35 \$2 \$1 \$I274 \$267 \$I1095 pmos$1
X$36 \$267 \$1 M1_conM9M10$1
X$37 \$1 \$9 \$I274 \$267 \$I870 pmos$1
X$38 \$2 \$1 \$I274 \$267 \$I1095 pmos$1
X$39 \$267 \$1 M1_conM9M10$1
X$40 \$1 \$9 \$I274 \$267 \$I870 pmos$1
X$41 \$2 \$1 \$I274 \$267 \$I1095 pmos$1
X$42 \$267 \$1 M1_conM9M10$1
X$43 \$1 \$9 \$I274 \$267 \$I870 pmos$1
X$44 \$2 \$1 \$I274 \$267 \$I1095 pmos$1
X$45 \$267 \$1 M1_conM9M10$1
X$46 \$1 \$9 \$I274 \$267 \$I870 pmos$1
X$47 \$2 \$1 \$I274 \$267 \$I1095 pmos$1
X$48 \$267 \$1 M1_conM9M10$1
X$49 \$1 \$9 \$I274 \$267 \$I870 pmos$1
X$50 \$2 \$1 \$I274 \$267 \$I1095 pmos$1
X$51 \$267 \$1 M1_conM9M10$1
X$52 \$1 \$9 \$I274 \$267 \$I870 pmos$1
X$53 \$2 \$1 \$I274 \$267 \$I1095 pmos$1
X$54 \$267 \$1 M1_conM9M10$1
X$55 \$1 \$9 \$I274 \$267 \$I870 pmos$1
X$56 \$2 \$1 \$I274 \$267 \$I1095 pmos$1
X$57 \$267 \$1 M1_conM9M10$1
X$58 \$1 \$9 \$I274 \$267 \$I870 pmos$1
X$59 \$2 \$1 \$I274 \$267 \$I1095 pmos$1
X$60 \$267 \$1 M1_conM9M10$1
X$61 \$1 \$9 \$I274 \$267 \$I870 pmos$1
X$62 \$2 \$1 \$I274 \$267 \$I1095 pmos$1
X$63 \$267 \$1 M1_conM9M10$1
X$64 \$1 \$9 \$I274 \$267 \$I870 pmos$1
X$65 \$2 \$1 \$I274 \$267 \$I1095 pmos$1
X$66 \$267 \$1 M1_conM9M10$1
X$67 \$1 \$9 \$I274 \$267 \$I870 pmos$1
X$68 \$2 \$1 \$I274 \$267 \$I1095 pmos$1
X$69 \$267 \$1 M1_conM9M10$1
X$70 \$1 \$9 \$I274 \$267 \$I870 pmos$1
X$71 \$2 \$1 \$I274 \$267 \$I1095 pmos$1
X$72 \$267 \$1 M1_conM9M10$1
X$73 \$1 \$9 \$I274 \$267 \$I870 pmos$1
X$74 \$2 \$1 \$I274 \$267 \$I1095 pmos$1
X$75 \$267 \$2 M1_conM9M10$1
X$76 \$267 \$2 M1_conM9M10$1
X$77 \$267 \$2 M1_conM9M10$1
X$78 \$267 \$2 M1_conM9M10$1
X$79 \$267 \$2 M1_conM9M10$1
X$80 \$267 \$2 M1_conM9M10$1
X$81 \$267 \$2 M1_conM9M10$1
X$82 \$267 \$2 M1_conM9M10$1
X$83 \$267 \$2 M1_conM9M10$1
X$84 \$267 \$2 M1_conM9M10$1
X$85 \$267 \$2 M1_conM9M10$1
X$86 \$267 \$2 M1_conM9M10$1
X$87 \$267 \$2 M1_conM9M10$1
X$88 \$267 \$2 M1_conM9M10$1
X$89 \$267 \$2 M1_conM9M10$1
X$90 \$267 \$2 M1_conM9M10$1
X$91 \$267 \$2 M1_conM9M10$1
X$92 \$267 \$2 M1_conM9M10$1
X$93 \$267 \$2 M1_conM9M10$1
X$94 \$267 \$2 M1_conM9M10$1
X$95 \$267 \$2 M1_conM9M10$1
X$96 \$267 \$2 M1_conM9M10$1
X$97 \$267 \$2 M1_conM9M10$1
X$98 \$267 \$2 M1_conM9M10$1
X$99 \$8 \$3 \$I274 \$267 \$I1070 pmos$1
X$100 \$267 \$3 M1_conM9M10$1
X$101 \$8 \$3 \$I274 \$267 \$I1070 pmos$1
X$102 \$267 \$3 M1_conM9M10$1
X$103 \$8 \$3 \$I274 \$267 \$I1070 pmos$1
X$104 \$267 \$3 M1_conM9M10$1
X$105 \$8 \$3 \$I274 \$267 \$I1070 pmos$1
X$106 \$267 \$3 M1_conM9M10$1
X$107 \$8 \$3 \$I274 \$267 \$I1070 pmos$1
X$108 \$267 \$3 M1_conM9M10$1
X$109 \$8 \$3 \$I274 \$267 \$I1070 pmos$1
X$110 \$267 \$3 M1_conM9M10$1
X$111 \$8 \$3 \$I274 \$267 \$I1070 pmos$1
X$112 \$267 \$3 M1_conM9M10$1
X$113 \$8 \$3 \$I274 \$267 \$I1070 pmos$1
X$114 \$267 \$3 M1_conM9M10$1
X$115 \$8 \$3 \$I274 \$267 \$I1070 pmos$1
X$116 \$267 \$3 M1_conM9M10$1
X$117 \$8 \$3 \$I274 \$267 \$I1070 pmos$1
X$118 \$267 \$3 M1_conM9M10$1
X$119 \$8 \$3 \$I274 \$267 \$I1070 pmos$1
X$120 \$267 \$3 M1_conM9M10$1
X$121 \$8 \$3 \$I274 \$267 \$I1070 pmos$1
X$122 \$267 \$3 M1_conM9M10$1
X$123 \$8 \$3 \$I274 \$267 \$I1070 pmos$1
X$124 \$267 \$3 M1_conM9M10$1
X$125 \$8 \$3 \$I274 \$267 \$I1070 pmos$1
X$126 \$267 \$3 M1_conM9M10$1
X$127 \$8 \$3 \$I274 \$267 \$I1070 pmos$1
X$128 \$267 \$3 M1_conM9M10$1
X$129 \$8 \$3 \$I274 \$267 \$I1070 pmos$1
X$130 \$267 \$3 M1_conM9M10$1
X$131 \$8 \$3 \$I274 \$267 \$I1070 pmos$1
X$132 \$267 \$3 M1_conM9M10$1
X$133 \$8 \$3 \$I274 \$267 \$I1070 pmos$1
X$134 \$267 \$3 M1_conM9M10$1
X$135 \$8 \$3 \$I274 \$267 \$I1070 pmos$1
X$136 \$267 \$3 M1_conM9M10$1
X$137 \$8 \$3 \$I274 \$267 \$I1070 pmos$1
X$138 \$267 \$3 M1_conM9M10$1
X$139 \$8 \$3 \$I274 \$267 \$I1070 pmos$1
X$140 \$267 \$3 M1_conM9M10$1
X$141 \$8 \$3 \$I274 \$267 \$I1070 pmos$1
X$142 \$267 \$3 M1_conM9M10$1
X$143 \$8 \$3 \$I274 \$267 \$I1070 pmos$1
X$144 \$267 \$3 M1_conM9M10$1
X$145 \$8 \$3 \$I274 \$267 \$I1070 pmos$1
X$146 \$267 \$3 M1_conM9M10$1
X$147 \$8 \$3 \$I274 \$267 \$I1070 pmos$1
X$148 \$7 \$14 \$I274 \$267 \$I1744 pmos$1
X$149 \$9 \$7 \$I274 \$267 \$I1743 pmos$1
X$150 \$267 \$7 M1_conM9M10$1
X$151 \$7 \$14 \$I274 \$267 \$I1744 pmos$1
X$152 \$9 \$7 \$I274 \$267 \$I1743 pmos$1
X$153 \$267 \$7 M1_conM9M10$1
X$154 \$7 \$14 \$I274 \$267 \$I1744 pmos$1
X$155 \$9 \$7 \$I274 \$267 \$I1743 pmos$1
X$156 \$267 \$7 M1_conM9M10$1
X$157 \$7 \$14 \$I274 \$267 \$I1744 pmos$1
X$158 \$9 \$7 \$I274 \$267 \$I1743 pmos$1
X$159 \$267 \$7 M1_conM9M10$1
X$160 \$7 \$14 \$I274 \$267 \$I1744 pmos$1
X$161 \$9 \$7 \$I274 \$267 \$I1743 pmos$1
X$162 \$267 \$7 M1_conM9M10$1
X$163 \$7 \$14 \$I274 \$267 \$I1744 pmos$1
X$164 \$9 \$7 \$I274 \$267 \$I1743 pmos$1
X$165 \$267 \$7 M1_conM9M10$1
X$166 \$7 \$14 \$I274 \$267 \$I1744 pmos$1
X$167 \$9 \$7 \$I274 \$267 \$I1743 pmos$1
X$168 \$267 \$7 M1_conM9M10$1
X$169 \$7 \$14 \$I274 \$267 \$I1744 pmos$1
X$170 \$9 \$7 \$I274 \$267 \$I1743 pmos$1
X$171 \$267 \$7 M1_conM9M10$1
X$172 \$7 \$14 \$I274 \$267 \$I1744 pmos$1
X$173 \$9 \$7 \$I274 \$267 \$I1743 pmos$1
X$174 \$267 \$7 M1_conM9M10$1
X$175 \$7 \$14 \$I274 \$267 \$I1744 pmos$1
X$176 \$9 \$7 \$I274 \$267 \$I1743 pmos$1
X$177 \$267 \$7 M1_conM9M10$1
X$178 \$7 \$14 \$I274 \$267 \$I1744 pmos$1
X$179 \$9 \$7 \$I274 \$267 \$I1743 pmos$1
X$180 \$267 \$7 M1_conM9M10$1
X$181 \$7 \$14 \$I274 \$267 \$I1744 pmos$1
X$182 \$9 \$7 \$I274 \$267 \$I1743 pmos$1
X$183 \$267 \$7 M1_conM9M10$1
X$184 \$7 \$14 \$I274 \$267 \$I1744 pmos$1
X$185 \$9 \$7 \$I274 \$267 \$I1743 pmos$1
X$186 \$267 \$7 M1_conM9M10$1
X$187 \$7 \$14 \$I274 \$267 \$I1744 pmos$1
X$188 \$9 \$7 \$I274 \$267 \$I1743 pmos$1
X$189 \$267 \$7 M1_conM9M10$1
X$190 \$7 \$14 \$I274 \$267 \$I1744 pmos$1
X$191 \$9 \$7 \$I274 \$267 \$I1743 pmos$1
X$192 \$267 \$7 M1_conM9M10$1
X$193 \$7 \$14 \$I274 \$267 \$I1744 pmos$1
X$194 \$9 \$7 \$I274 \$267 \$I1743 pmos$1
X$195 \$267 \$7 M1_conM9M10$1
X$196 \$7 \$14 \$I274 \$267 \$I1744 pmos$1
X$197 \$9 \$7 \$I274 \$267 \$I1743 pmos$1
X$198 \$267 \$7 M1_conM9M10$1
X$199 \$7 \$14 \$I274 \$267 \$I1744 pmos$1
X$200 \$9 \$7 \$I274 \$267 \$I1743 pmos$1
X$201 \$267 \$7 M1_conM9M10$1
X$202 \$7 \$14 \$I274 \$267 \$I1744 pmos$1
X$203 \$9 \$7 \$I274 \$267 \$I1743 pmos$1
X$204 \$267 \$7 M1_conM9M10$1
X$205 \$7 \$14 \$I274 \$267 \$I1744 pmos$1
X$206 \$9 \$7 \$I274 \$267 \$I1743 pmos$1
X$207 \$267 \$7 M1_conM9M10$1
X$208 \$7 \$14 \$I274 \$267 \$I1744 pmos$1
X$209 \$9 \$7 \$I274 \$267 \$I1743 pmos$1
X$210 \$267 \$7 M1_conM9M10$1
X$211 \$7 \$14 \$I274 \$267 \$I1744 pmos$1
X$212 \$9 \$7 \$I274 \$267 \$I1743 pmos$1
X$213 \$267 \$7 M1_conM9M10$1
X$214 \$7 \$14 \$I274 \$267 \$I1744 pmos$1
X$215 \$9 \$7 \$I274 \$267 \$I1743 pmos$1
X$216 \$267 \$7 M1_conM9M10$1
X$217 \$7 \$14 \$I274 \$267 \$I1744 pmos$1
X$218 \$9 \$7 \$I274 \$267 \$I1743 pmos$1
X$219 \$267 \$7 M1_conM9M10$1
X$220 \$7 \$14 \$I274 \$267 \$I1744 pmos$1
X$221 \$9 \$7 \$I274 \$267 \$I1743 pmos$1
X$222 \$15 \$8 \$I274 \$267 \$I1764 pmos$1
X$223 \$267 \$8 M1_conM9M10$1
X$224 \$15 \$8 \$I274 \$267 \$I1764 pmos$1
X$225 \$267 \$8 M1_conM9M10$1
X$226 \$15 \$8 \$I274 \$267 \$I1764 pmos$1
X$227 \$267 \$8 M1_conM9M10$1
X$228 \$15 \$8 \$I274 \$267 \$I1764 pmos$1
X$229 \$267 \$8 M1_conM9M10$1
X$230 \$15 \$8 \$I274 \$267 \$I1764 pmos$1
X$231 \$267 \$8 M1_conM9M10$1
X$232 \$15 \$8 \$I274 \$267 \$I1764 pmos$1
X$233 \$267 \$8 M1_conM9M10$1
X$234 \$15 \$8 \$I274 \$267 \$I1764 pmos$1
X$235 \$267 \$8 M1_conM9M10$1
X$236 \$15 \$8 \$I274 \$267 \$I1764 pmos$1
X$237 \$267 \$8 M1_conM9M10$1
X$238 \$15 \$8 \$I274 \$267 \$I1764 pmos$1
X$239 \$267 \$8 M1_conM9M10$1
X$240 \$15 \$8 \$I274 \$267 \$I1764 pmos$1
X$241 \$267 \$8 M1_conM9M10$1
X$242 \$15 \$8 \$I274 \$267 \$I1764 pmos$1
X$243 \$267 \$8 M1_conM9M10$1
X$244 \$15 \$8 \$I274 \$267 \$I1764 pmos$1
X$245 \$267 \$8 M1_conM9M10$1
X$246 \$15 \$8 \$I274 \$267 \$I1764 pmos$1
X$247 \$267 \$8 M1_conM9M10$1
X$248 \$15 \$8 \$I274 \$267 \$I1764 pmos$1
X$249 \$267 \$8 M1_conM9M10$1
X$250 \$15 \$8 \$I274 \$267 \$I1764 pmos$1
X$251 \$267 \$8 M1_conM9M10$1
X$252 \$15 \$8 \$I274 \$267 \$I1764 pmos$1
X$253 \$267 \$8 M1_conM9M10$1
X$254 \$15 \$8 \$I274 \$267 \$I1764 pmos$1
X$255 \$267 \$8 M1_conM9M10$1
X$256 \$15 \$8 \$I274 \$267 \$I1764 pmos$1
X$257 \$267 \$8 M1_conM9M10$1
X$258 \$15 \$8 \$I274 \$267 \$I1764 pmos$1
X$259 \$267 \$8 M1_conM9M10$1
X$260 \$15 \$8 \$I274 \$267 \$I1764 pmos$1
X$261 \$267 \$8 M1_conM9M10$1
X$262 \$15 \$8 \$I274 \$267 \$I1764 pmos$1
X$263 \$267 \$8 M1_conM9M10$1
X$264 \$15 \$8 \$I274 \$267 \$I1764 pmos$1
X$265 \$267 \$8 M1_conM9M10$1
X$266 \$15 \$8 \$I274 \$267 \$I1764 pmos$1
X$267 \$267 \$8 M1_conM9M10$1
X$268 \$15 \$8 \$I274 \$267 \$I1764 pmos$1
X$269 \$267 \$8 M1_conM9M10$1
X$270 \$15 \$8 \$I274 \$267 \$I1764 pmos$1
X$271 \$267 \$9 M1_conM9M10$1
X$272 \$267 \$9 M1_conM9M10$1
X$273 \$267 \$9 M1_conM9M10$1
X$274 \$267 \$9 M1_conM9M10$1
X$275 \$267 \$9 M1_conM9M10$1
X$276 \$267 \$9 M1_conM9M10$1
X$277 \$267 \$9 M1_conM9M10$1
X$278 \$267 \$9 M1_conM9M10$1
X$279 \$267 \$9 M1_conM9M10$1
X$280 \$267 \$9 M1_conM9M10$1
X$281 \$267 \$9 M1_conM9M10$1
X$282 \$267 \$9 M1_conM9M10$1
X$283 \$267 \$9 M1_conM9M10$1
X$284 \$267 \$9 M1_conM9M10$1
X$285 \$267 \$9 M1_conM9M10$1
X$286 \$267 \$9 M1_conM9M10$1
X$287 \$267 \$9 M1_conM9M10$1
X$288 \$267 \$9 M1_conM9M10$1
X$289 \$267 \$9 M1_conM9M10$1
X$290 \$267 \$9 M1_conM9M10$1
X$291 \$267 \$9 M1_conM9M10$1
X$292 \$267 \$9 M1_conM9M10$1
X$293 \$267 \$9 M1_conM9M10$1
X$294 \$267 \$9 M1_conM9M10$1
X$295 \$13 \$20 \$I274 \$267 \$I1697 pmos$1
X$296 \$14 \$13 \$I274 \$267 \$I1695 pmos$1
X$297 \$267 \$13 M1_conM9M10$1
X$298 \$13 \$20 \$I274 \$267 \$I1697 pmos$1
X$299 \$14 \$13 \$I274 \$267 \$I1695 pmos$1
X$300 \$267 \$13 M1_conM9M10$1
X$301 \$13 \$20 \$I274 \$267 \$I1697 pmos$1
X$302 \$14 \$13 \$I274 \$267 \$I1695 pmos$1
X$303 \$267 \$13 M1_conM9M10$1
X$304 \$13 \$20 \$I274 \$267 \$I1697 pmos$1
X$305 \$14 \$13 \$I274 \$267 \$I1695 pmos$1
X$306 \$267 \$13 M1_conM9M10$1
X$307 \$13 \$20 \$I274 \$267 \$I1697 pmos$1
X$308 \$14 \$13 \$I274 \$267 \$I1695 pmos$1
X$309 \$267 \$13 M1_conM9M10$1
X$310 \$13 \$20 \$I274 \$267 \$I1697 pmos$1
X$311 \$14 \$13 \$I274 \$267 \$I1695 pmos$1
X$312 \$267 \$13 M1_conM9M10$1
X$313 \$13 \$20 \$I274 \$267 \$I1697 pmos$1
X$314 \$14 \$13 \$I274 \$267 \$I1695 pmos$1
X$315 \$267 \$13 M1_conM9M10$1
X$316 \$13 \$20 \$I274 \$267 \$I1697 pmos$1
X$317 \$14 \$13 \$I274 \$267 \$I1695 pmos$1
X$318 \$267 \$13 M1_conM9M10$1
X$319 \$13 \$20 \$I274 \$267 \$I1697 pmos$1
X$320 \$14 \$13 \$I274 \$267 \$I1695 pmos$1
X$321 \$267 \$13 M1_conM9M10$1
X$322 \$13 \$20 \$I274 \$267 \$I1697 pmos$1
X$323 \$14 \$13 \$I274 \$267 \$I1695 pmos$1
X$324 \$267 \$13 M1_conM9M10$1
X$325 \$13 \$20 \$I274 \$267 \$I1697 pmos$1
X$326 \$14 \$13 \$I274 \$267 \$I1695 pmos$1
X$327 \$267 \$13 M1_conM9M10$1
X$328 \$13 \$20 \$I274 \$267 \$I1697 pmos$1
X$329 \$14 \$13 \$I274 \$267 \$I1695 pmos$1
X$330 \$267 \$13 M1_conM9M10$1
X$331 \$13 \$20 \$I274 \$267 \$I1697 pmos$1
X$332 \$14 \$13 \$I274 \$267 \$I1695 pmos$1
X$333 \$267 \$13 M1_conM9M10$1
X$334 \$13 \$20 \$I274 \$267 \$I1697 pmos$1
X$335 \$14 \$13 \$I274 \$267 \$I1695 pmos$1
X$336 \$267 \$13 M1_conM9M10$1
X$337 \$13 \$20 \$I274 \$267 \$I1697 pmos$1
X$338 \$14 \$13 \$I274 \$267 \$I1695 pmos$1
X$339 \$267 \$13 M1_conM9M10$1
X$340 \$13 \$20 \$I274 \$267 \$I1697 pmos$1
X$341 \$14 \$13 \$I274 \$267 \$I1695 pmos$1
X$342 \$267 \$13 M1_conM9M10$1
X$343 \$13 \$20 \$I274 \$267 \$I1697 pmos$1
X$344 \$14 \$13 \$I274 \$267 \$I1695 pmos$1
X$345 \$267 \$13 M1_conM9M10$1
X$346 \$13 \$20 \$I274 \$267 \$I1697 pmos$1
X$347 \$14 \$13 \$I274 \$267 \$I1695 pmos$1
X$348 \$267 \$13 M1_conM9M10$1
X$349 \$13 \$20 \$I274 \$267 \$I1697 pmos$1
X$350 \$14 \$13 \$I274 \$267 \$I1695 pmos$1
X$351 \$267 \$13 M1_conM9M10$1
X$352 \$13 \$20 \$I274 \$267 \$I1697 pmos$1
X$353 \$14 \$13 \$I274 \$267 \$I1695 pmos$1
X$354 \$267 \$13 M1_conM9M10$1
X$355 \$13 \$20 \$I274 \$267 \$I1697 pmos$1
X$356 \$14 \$13 \$I274 \$267 \$I1695 pmos$1
X$357 \$267 \$13 M1_conM9M10$1
X$358 \$13 \$20 \$I274 \$267 \$I1697 pmos$1
X$359 \$14 \$13 \$I274 \$267 \$I1695 pmos$1
X$360 \$267 \$13 M1_conM9M10$1
X$361 \$13 \$20 \$I274 \$267 \$I1697 pmos$1
X$362 \$14 \$13 \$I274 \$267 \$I1695 pmos$1
X$363 \$267 \$13 M1_conM9M10$1
X$364 \$13 \$20 \$I274 \$267 \$I1697 pmos$1
X$365 \$14 \$13 \$I274 \$267 \$I1695 pmos$1
X$366 \$267 \$13 M1_conM9M10$1
X$367 \$13 \$20 \$I274 \$267 \$I1697 pmos$1
X$368 \$14 \$13 \$I274 \$267 \$I1695 pmos$1
X$369 \$267 \$14 M1_conM9M10$1
X$370 \$267 \$14 M1_conM9M10$1
X$371 \$267 \$14 M1_conM9M10$1
X$372 \$267 \$14 M1_conM9M10$1
X$373 \$267 \$14 M1_conM9M10$1
X$374 \$267 \$14 M1_conM9M10$1
X$375 \$267 \$14 M1_conM9M10$1
X$376 \$267 \$14 M1_conM9M10$1
X$377 \$267 \$14 M1_conM9M10$1
X$378 \$267 \$14 M1_conM9M10$1
X$379 \$267 \$14 M1_conM9M10$1
X$380 \$267 \$14 M1_conM9M10$1
X$381 \$267 \$14 M1_conM9M10$1
X$382 \$267 \$14 M1_conM9M10$1
X$383 \$267 \$14 M1_conM9M10$1
X$384 \$267 \$14 M1_conM9M10$1
X$385 \$267 \$14 M1_conM9M10$1
X$386 \$267 \$14 M1_conM9M10$1
X$387 \$267 \$14 M1_conM9M10$1
X$388 \$267 \$14 M1_conM9M10$1
X$389 \$267 \$14 M1_conM9M10$1
X$390 \$267 \$14 M1_conM9M10$1
X$391 \$267 \$14 M1_conM9M10$1
X$392 \$267 \$14 M1_conM9M10$1
X$393 \$19 \$15 \$I274 \$267 \$I1763 pmos$1
X$394 \$267 \$15 M1_conM9M10$1
X$395 \$19 \$15 \$I274 \$267 \$I1763 pmos$1
X$396 \$267 \$15 M1_conM9M10$1
X$397 \$19 \$15 \$I274 \$267 \$I1763 pmos$1
X$398 \$267 \$15 M1_conM9M10$1
X$399 \$19 \$15 \$I274 \$267 \$I1763 pmos$1
X$400 \$267 \$15 M1_conM9M10$1
X$401 \$19 \$15 \$I274 \$267 \$I1763 pmos$1
X$402 \$267 \$15 M1_conM9M10$1
X$403 \$19 \$15 \$I274 \$267 \$I1763 pmos$1
X$404 \$267 \$15 M1_conM9M10$1
X$405 \$19 \$15 \$I274 \$267 \$I1763 pmos$1
X$406 \$267 \$15 M1_conM9M10$1
X$407 \$19 \$15 \$I274 \$267 \$I1763 pmos$1
X$408 \$267 \$15 M1_conM9M10$1
X$409 \$19 \$15 \$I274 \$267 \$I1763 pmos$1
X$410 \$267 \$15 M1_conM9M10$1
X$411 \$19 \$15 \$I274 \$267 \$I1763 pmos$1
X$412 \$267 \$15 M1_conM9M10$1
X$413 \$19 \$15 \$I274 \$267 \$I1763 pmos$1
X$414 \$267 \$15 M1_conM9M10$1
X$415 \$19 \$15 \$I274 \$267 \$I1763 pmos$1
X$416 \$267 \$15 M1_conM9M10$1
X$417 \$19 \$15 \$I274 \$267 \$I1763 pmos$1
X$418 \$267 \$15 M1_conM9M10$1
X$419 \$19 \$15 \$I274 \$267 \$I1763 pmos$1
X$420 \$267 \$15 M1_conM9M10$1
X$421 \$19 \$15 \$I274 \$267 \$I1763 pmos$1
X$422 \$267 \$15 M1_conM9M10$1
X$423 \$19 \$15 \$I274 \$267 \$I1763 pmos$1
X$424 \$267 \$15 M1_conM9M10$1
X$425 \$19 \$15 \$I274 \$267 \$I1763 pmos$1
X$426 \$267 \$15 M1_conM9M10$1
X$427 \$19 \$15 \$I274 \$267 \$I1763 pmos$1
X$428 \$267 \$15 M1_conM9M10$1
X$429 \$19 \$15 \$I274 \$267 \$I1763 pmos$1
X$430 \$267 \$15 M1_conM9M10$1
X$431 \$19 \$15 \$I274 \$267 \$I1763 pmos$1
X$432 \$267 \$15 M1_conM9M10$1
X$433 \$19 \$15 \$I274 \$267 \$I1763 pmos$1
X$434 \$267 \$15 M1_conM9M10$1
X$435 \$19 \$15 \$I274 \$267 \$I1763 pmos$1
X$436 \$267 \$15 M1_conM9M10$1
X$437 \$19 \$15 \$I274 \$267 \$I1763 pmos$1
X$438 \$267 \$15 M1_conM9M10$1
X$439 \$19 \$15 \$I274 \$267 \$I1763 pmos$1
X$440 \$267 \$15 M1_conM9M10$1
X$441 \$19 \$15 \$I274 \$267 \$I1763 pmos$1
X$442 \$20 \$19 \$I274 \$267 \$I1762 pmos$1
X$443 \$267 \$19 M1_conM9M10$1
X$444 \$20 \$19 \$I274 \$267 \$I1762 pmos$1
X$445 \$267 \$19 M1_conM9M10$1
X$446 \$20 \$19 \$I274 \$267 \$I1762 pmos$1
X$447 \$267 \$19 M1_conM9M10$1
X$448 \$20 \$19 \$I274 \$267 \$I1762 pmos$1
X$449 \$267 \$19 M1_conM9M10$1
X$450 \$20 \$19 \$I274 \$267 \$I1762 pmos$1
X$451 \$267 \$19 M1_conM9M10$1
X$452 \$20 \$19 \$I274 \$267 \$I1762 pmos$1
X$453 \$267 \$19 M1_conM9M10$1
X$454 \$20 \$19 \$I274 \$267 \$I1762 pmos$1
X$455 \$267 \$19 M1_conM9M10$1
X$456 \$20 \$19 \$I274 \$267 \$I1762 pmos$1
X$457 \$267 \$19 M1_conM9M10$1
X$458 \$20 \$19 \$I274 \$267 \$I1762 pmos$1
X$459 \$267 \$19 M1_conM9M10$1
X$460 \$20 \$19 \$I274 \$267 \$I1762 pmos$1
X$461 \$267 \$19 M1_conM9M10$1
X$462 \$20 \$19 \$I274 \$267 \$I1762 pmos$1
X$463 \$267 \$19 M1_conM9M10$1
X$464 \$20 \$19 \$I274 \$267 \$I1762 pmos$1
X$465 \$267 \$19 M1_conM9M10$1
X$466 \$20 \$19 \$I274 \$267 \$I1762 pmos$1
X$467 \$267 \$19 M1_conM9M10$1
X$468 \$20 \$19 \$I274 \$267 \$I1762 pmos$1
X$469 \$267 \$19 M1_conM9M10$1
X$470 \$20 \$19 \$I274 \$267 \$I1762 pmos$1
X$471 \$267 \$19 M1_conM9M10$1
X$472 \$20 \$19 \$I274 \$267 \$I1762 pmos$1
X$473 \$267 \$19 M1_conM9M10$1
X$474 \$20 \$19 \$I274 \$267 \$I1762 pmos$1
X$475 \$267 \$19 M1_conM9M10$1
X$476 \$20 \$19 \$I274 \$267 \$I1762 pmos$1
X$477 \$267 \$19 M1_conM9M10$1
X$478 \$20 \$19 \$I274 \$267 \$I1762 pmos$1
X$479 \$267 \$19 M1_conM9M10$1
X$480 \$20 \$19 \$I274 \$267 \$I1762 pmos$1
X$481 \$267 \$19 M1_conM9M10$1
X$482 \$20 \$19 \$I274 \$267 \$I1762 pmos$1
X$483 \$267 \$19 M1_conM9M10$1
X$484 \$20 \$19 \$I274 \$267 \$I1762 pmos$1
X$485 \$267 \$19 M1_conM9M10$1
X$486 \$20 \$19 \$I274 \$267 \$I1762 pmos$1
X$487 \$267 \$19 M1_conM9M10$1
X$488 \$20 \$19 \$I274 \$267 \$I1762 pmos$1
X$489 \$267 \$19 M1_conM9M10$1
X$490 \$20 \$19 \$I274 \$267 \$I1762 pmos$1
X$491 \$267 \$20 M1_conM9M10$1
X$492 \$267 \$20 M1_conM9M10$1
X$493 \$267 \$20 M1_conM9M10$1
X$494 \$267 \$20 M1_conM9M10$1
X$495 \$267 \$20 M1_conM9M10$1
X$496 \$267 \$20 M1_conM9M10$1
X$497 \$267 \$20 M1_conM9M10$1
X$498 \$267 \$20 M1_conM9M10$1
X$499 \$267 \$20 M1_conM9M10$1
X$500 \$267 \$20 M1_conM9M10$1
X$501 \$267 \$20 M1_conM9M10$1
X$502 \$267 \$20 M1_conM9M10$1
X$503 \$267 \$20 M1_conM9M10$1
X$504 \$267 \$20 M1_conM9M10$1
X$505 \$267 \$20 M1_conM9M10$1
X$506 \$267 \$20 M1_conM9M10$1
X$507 \$267 \$20 M1_conM9M10$1
X$508 \$267 \$20 M1_conM9M10$1
X$509 \$267 \$20 M1_conM9M10$1
X$510 \$267 \$20 M1_conM9M10$1
X$511 \$267 \$20 M1_conM9M10$1
X$512 \$267 \$20 M1_conM9M10$1
X$513 \$267 \$20 M1_conM9M10$1
X$514 \$267 \$20 M1_conM9M10$1
M$1 \$2 \$I1095 \$1 \$I274 sg13_lv_pmos L=0.35u W=1.37u AS=0.4658p AD=0.2603p
+ PS=3.42u PD=1.75u
M$2 \$1 \$I870 \$9 \$I274 sg13_lv_pmos L=0.35u W=1.37u AS=0.2603p AD=0.2603p
+ PS=1.75u PD=1.75u
M$3 \$9 \$I1743 \$7 \$I274 sg13_lv_pmos L=0.35u W=1.37u AS=0.2603p AD=0.2603p
+ PS=1.75u PD=1.75u
M$4 \$7 \$I1744 \$14 \$I274 sg13_lv_pmos L=0.35u W=1.37u AS=0.2603p AD=0.2603p
+ PS=1.75u PD=1.75u
M$5 \$14 \$I1695 \$13 \$I274 sg13_lv_pmos L=0.35u W=1.37u AS=0.2603p AD=0.2603p
+ PS=1.75u PD=1.75u
M$6 \$13 \$I1697 \$20 \$I274 sg13_lv_pmos L=0.35u W=1.37u AS=0.2603p AD=0.2603p
+ PS=1.75u PD=1.75u
M$7 \$20 \$I1762 \$19 \$I274 sg13_lv_pmos L=0.35u W=1.37u AS=0.2603p AD=0.2603p
+ PS=1.75u PD=1.75u
M$8 \$19 \$I1763 \$15 \$I274 sg13_lv_pmos L=0.35u W=1.37u AS=0.2603p AD=0.2603p
+ PS=1.75u PD=1.75u
M$9 \$15 \$I1764 \$8 \$I274 sg13_lv_pmos L=0.35u W=1.37u AS=0.2603p AD=0.2603p
+ PS=1.75u PD=1.75u
M$10 \$8 \$I1070 \$3 \$I274 sg13_lv_pmos L=0.35u W=1.37u AS=0.2603p AD=0.4658p
+ PS=1.75u PD=3.42u
M$11 \$2 \$I1095 \$1 \$I274 sg13_lv_pmos L=0.35u W=1.37u AS=0.4658p AD=0.2603p
+ PS=3.42u PD=1.75u
M$12 \$1 \$I870 \$9 \$I274 sg13_lv_pmos L=0.35u W=1.37u AS=0.2603p AD=0.2603p
+ PS=1.75u PD=1.75u
M$13 \$9 \$I1743 \$7 \$I274 sg13_lv_pmos L=0.35u W=1.37u AS=0.2603p AD=0.2603p
+ PS=1.75u PD=1.75u
M$14 \$7 \$I1744 \$14 \$I274 sg13_lv_pmos L=0.35u W=1.37u AS=0.2603p AD=0.2603p
+ PS=1.75u PD=1.75u
M$15 \$14 \$I1695 \$13 \$I274 sg13_lv_pmos L=0.35u W=1.37u AS=0.2603p
+ AD=0.2603p PS=1.75u PD=1.75u
M$16 \$13 \$I1697 \$20 \$I274 sg13_lv_pmos L=0.35u W=1.37u AS=0.2603p
+ AD=0.2603p PS=1.75u PD=1.75u
M$17 \$20 \$I1762 \$19 \$I274 sg13_lv_pmos L=0.35u W=1.37u AS=0.2603p
+ AD=0.2603p PS=1.75u PD=1.75u
M$18 \$19 \$I1763 \$15 \$I274 sg13_lv_pmos L=0.35u W=1.37u AS=0.2603p
+ AD=0.2603p PS=1.75u PD=1.75u
M$19 \$15 \$I1764 \$8 \$I274 sg13_lv_pmos L=0.35u W=1.37u AS=0.2603p AD=0.2603p
+ PS=1.75u PD=1.75u
M$20 \$8 \$I1070 \$3 \$I274 sg13_lv_pmos L=0.35u W=1.37u AS=0.2603p AD=0.4658p
+ PS=1.75u PD=3.42u
M$21 \$2 \$I1095 \$1 \$I274 sg13_lv_pmos L=0.35u W=1.37u AS=0.4658p AD=0.2603p
+ PS=3.42u PD=1.75u
M$22 \$1 \$I870 \$9 \$I274 sg13_lv_pmos L=0.35u W=1.37u AS=0.2603p AD=0.2603p
+ PS=1.75u PD=1.75u
M$23 \$9 \$I1743 \$7 \$I274 sg13_lv_pmos L=0.35u W=1.37u AS=0.2603p AD=0.2603p
+ PS=1.75u PD=1.75u
M$24 \$7 \$I1744 \$14 \$I274 sg13_lv_pmos L=0.35u W=1.37u AS=0.2603p AD=0.2603p
+ PS=1.75u PD=1.75u
M$25 \$14 \$I1695 \$13 \$I274 sg13_lv_pmos L=0.35u W=1.37u AS=0.2603p
+ AD=0.2603p PS=1.75u PD=1.75u
M$26 \$13 \$I1697 \$20 \$I274 sg13_lv_pmos L=0.35u W=1.37u AS=0.2603p
+ AD=0.2603p PS=1.75u PD=1.75u
M$27 \$20 \$I1762 \$19 \$I274 sg13_lv_pmos L=0.35u W=1.37u AS=0.2603p
+ AD=0.2603p PS=1.75u PD=1.75u
M$28 \$19 \$I1763 \$15 \$I274 sg13_lv_pmos L=0.35u W=1.37u AS=0.2603p
+ AD=0.2603p PS=1.75u PD=1.75u
M$29 \$15 \$I1764 \$8 \$I274 sg13_lv_pmos L=0.35u W=1.37u AS=0.2603p AD=0.2603p
+ PS=1.75u PD=1.75u
M$30 \$8 \$I1070 \$3 \$I274 sg13_lv_pmos L=0.35u W=1.37u AS=0.2603p AD=0.4658p
+ PS=1.75u PD=3.42u
M$31 \$2 \$I1095 \$1 \$I274 sg13_lv_pmos L=0.35u W=1.37u AS=0.4658p AD=0.2603p
+ PS=3.42u PD=1.75u
M$32 \$1 \$I870 \$9 \$I274 sg13_lv_pmos L=0.35u W=1.37u AS=0.2603p AD=0.2603p
+ PS=1.75u PD=1.75u
M$33 \$9 \$I1743 \$7 \$I274 sg13_lv_pmos L=0.35u W=1.37u AS=0.2603p AD=0.2603p
+ PS=1.75u PD=1.75u
M$34 \$7 \$I1744 \$14 \$I274 sg13_lv_pmos L=0.35u W=1.37u AS=0.2603p AD=0.2603p
+ PS=1.75u PD=1.75u
M$35 \$14 \$I1695 \$13 \$I274 sg13_lv_pmos L=0.35u W=1.37u AS=0.2603p
+ AD=0.2603p PS=1.75u PD=1.75u
M$36 \$13 \$I1697 \$20 \$I274 sg13_lv_pmos L=0.35u W=1.37u AS=0.2603p
+ AD=0.2603p PS=1.75u PD=1.75u
M$37 \$20 \$I1762 \$19 \$I274 sg13_lv_pmos L=0.35u W=1.37u AS=0.2603p
+ AD=0.2603p PS=1.75u PD=1.75u
M$38 \$19 \$I1763 \$15 \$I274 sg13_lv_pmos L=0.35u W=1.37u AS=0.2603p
+ AD=0.2603p PS=1.75u PD=1.75u
M$39 \$15 \$I1764 \$8 \$I274 sg13_lv_pmos L=0.35u W=1.37u AS=0.2603p AD=0.2603p
+ PS=1.75u PD=1.75u
M$40 \$8 \$I1070 \$3 \$I274 sg13_lv_pmos L=0.35u W=1.37u AS=0.2603p AD=0.4658p
+ PS=1.75u PD=3.42u
M$41 \$2 \$I1095 \$1 \$I274 sg13_lv_pmos L=0.35u W=1.37u AS=0.4658p AD=0.2603p
+ PS=3.42u PD=1.75u
M$42 \$1 \$I870 \$9 \$I274 sg13_lv_pmos L=0.35u W=1.37u AS=0.2603p AD=0.2603p
+ PS=1.75u PD=1.75u
M$43 \$9 \$I1743 \$7 \$I274 sg13_lv_pmos L=0.35u W=1.37u AS=0.2603p AD=0.2603p
+ PS=1.75u PD=1.75u
M$44 \$7 \$I1744 \$14 \$I274 sg13_lv_pmos L=0.35u W=1.37u AS=0.2603p AD=0.2603p
+ PS=1.75u PD=1.75u
M$45 \$14 \$I1695 \$13 \$I274 sg13_lv_pmos L=0.35u W=1.37u AS=0.2603p
+ AD=0.2603p PS=1.75u PD=1.75u
M$46 \$13 \$I1697 \$20 \$I274 sg13_lv_pmos L=0.35u W=1.37u AS=0.2603p
+ AD=0.2603p PS=1.75u PD=1.75u
M$47 \$20 \$I1762 \$19 \$I274 sg13_lv_pmos L=0.35u W=1.37u AS=0.2603p
+ AD=0.2603p PS=1.75u PD=1.75u
M$48 \$19 \$I1763 \$15 \$I274 sg13_lv_pmos L=0.35u W=1.37u AS=0.2603p
+ AD=0.2603p PS=1.75u PD=1.75u
M$49 \$15 \$I1764 \$8 \$I274 sg13_lv_pmos L=0.35u W=1.37u AS=0.2603p AD=0.2603p
+ PS=1.75u PD=1.75u
M$50 \$8 \$I1070 \$3 \$I274 sg13_lv_pmos L=0.35u W=1.37u AS=0.2603p AD=0.4658p
+ PS=1.75u PD=3.42u
M$51 \$2 \$I1095 \$1 \$I274 sg13_lv_pmos L=0.35u W=1.37u AS=0.4658p AD=0.2603p
+ PS=3.42u PD=1.75u
M$52 \$1 \$I870 \$9 \$I274 sg13_lv_pmos L=0.35u W=1.37u AS=0.2603p AD=0.2603p
+ PS=1.75u PD=1.75u
M$53 \$9 \$I1743 \$7 \$I274 sg13_lv_pmos L=0.35u W=1.37u AS=0.2603p AD=0.2603p
+ PS=1.75u PD=1.75u
M$54 \$7 \$I1744 \$14 \$I274 sg13_lv_pmos L=0.35u W=1.37u AS=0.2603p AD=0.2603p
+ PS=1.75u PD=1.75u
M$55 \$14 \$I1695 \$13 \$I274 sg13_lv_pmos L=0.35u W=1.37u AS=0.2603p
+ AD=0.2603p PS=1.75u PD=1.75u
M$56 \$13 \$I1697 \$20 \$I274 sg13_lv_pmos L=0.35u W=1.37u AS=0.2603p
+ AD=0.2603p PS=1.75u PD=1.75u
M$57 \$20 \$I1762 \$19 \$I274 sg13_lv_pmos L=0.35u W=1.37u AS=0.2603p
+ AD=0.2603p PS=1.75u PD=1.75u
M$58 \$19 \$I1763 \$15 \$I274 sg13_lv_pmos L=0.35u W=1.37u AS=0.2603p
+ AD=0.2603p PS=1.75u PD=1.75u
M$59 \$15 \$I1764 \$8 \$I274 sg13_lv_pmos L=0.35u W=1.37u AS=0.2603p AD=0.2603p
+ PS=1.75u PD=1.75u
M$60 \$8 \$I1070 \$3 \$I274 sg13_lv_pmos L=0.35u W=1.37u AS=0.2603p AD=0.4658p
+ PS=1.75u PD=3.42u
M$61 \$2 \$I1095 \$1 \$I274 sg13_lv_pmos L=0.35u W=1.37u AS=0.4658p AD=0.2603p
+ PS=3.42u PD=1.75u
M$62 \$1 \$I870 \$9 \$I274 sg13_lv_pmos L=0.35u W=1.37u AS=0.2603p AD=0.2603p
+ PS=1.75u PD=1.75u
M$63 \$9 \$I1743 \$7 \$I274 sg13_lv_pmos L=0.35u W=1.37u AS=0.2603p AD=0.2603p
+ PS=1.75u PD=1.75u
M$64 \$7 \$I1744 \$14 \$I274 sg13_lv_pmos L=0.35u W=1.37u AS=0.2603p AD=0.2603p
+ PS=1.75u PD=1.75u
M$65 \$14 \$I1695 \$13 \$I274 sg13_lv_pmos L=0.35u W=1.37u AS=0.2603p
+ AD=0.2603p PS=1.75u PD=1.75u
M$66 \$13 \$I1697 \$20 \$I274 sg13_lv_pmos L=0.35u W=1.37u AS=0.2603p
+ AD=0.2603p PS=1.75u PD=1.75u
M$67 \$20 \$I1762 \$19 \$I274 sg13_lv_pmos L=0.35u W=1.37u AS=0.2603p
+ AD=0.2603p PS=1.75u PD=1.75u
M$68 \$19 \$I1763 \$15 \$I274 sg13_lv_pmos L=0.35u W=1.37u AS=0.2603p
+ AD=0.2603p PS=1.75u PD=1.75u
M$69 \$15 \$I1764 \$8 \$I274 sg13_lv_pmos L=0.35u W=1.37u AS=0.2603p AD=0.2603p
+ PS=1.75u PD=1.75u
M$70 \$8 \$I1070 \$3 \$I274 sg13_lv_pmos L=0.35u W=1.37u AS=0.2603p AD=0.4658p
+ PS=1.75u PD=3.42u
M$71 \$2 \$I1095 \$1 \$I274 sg13_lv_pmos L=0.35u W=1.37u AS=0.4658p AD=0.2603p
+ PS=3.42u PD=1.75u
M$72 \$1 \$I870 \$9 \$I274 sg13_lv_pmos L=0.35u W=1.37u AS=0.2603p AD=0.2603p
+ PS=1.75u PD=1.75u
M$73 \$9 \$I1743 \$7 \$I274 sg13_lv_pmos L=0.35u W=1.37u AS=0.2603p AD=0.2603p
+ PS=1.75u PD=1.75u
M$74 \$7 \$I1744 \$14 \$I274 sg13_lv_pmos L=0.35u W=1.37u AS=0.2603p AD=0.2603p
+ PS=1.75u PD=1.75u
M$75 \$14 \$I1695 \$13 \$I274 sg13_lv_pmos L=0.35u W=1.37u AS=0.2603p
+ AD=0.2603p PS=1.75u PD=1.75u
M$76 \$13 \$I1697 \$20 \$I274 sg13_lv_pmos L=0.35u W=1.37u AS=0.2603p
+ AD=0.2603p PS=1.75u PD=1.75u
M$77 \$20 \$I1762 \$19 \$I274 sg13_lv_pmos L=0.35u W=1.37u AS=0.2603p
+ AD=0.2603p PS=1.75u PD=1.75u
M$78 \$19 \$I1763 \$15 \$I274 sg13_lv_pmos L=0.35u W=1.37u AS=0.2603p
+ AD=0.2603p PS=1.75u PD=1.75u
M$79 \$15 \$I1764 \$8 \$I274 sg13_lv_pmos L=0.35u W=1.37u AS=0.2603p AD=0.2603p
+ PS=1.75u PD=1.75u
M$80 \$8 \$I1070 \$3 \$I274 sg13_lv_pmos L=0.35u W=1.37u AS=0.2603p AD=0.4658p
+ PS=1.75u PD=3.42u
M$81 \$2 \$I1095 \$1 \$I274 sg13_lv_pmos L=0.35u W=1.37u AS=0.4658p AD=0.2603p
+ PS=3.42u PD=1.75u
M$82 \$1 \$I870 \$9 \$I274 sg13_lv_pmos L=0.35u W=1.37u AS=0.2603p AD=0.2603p
+ PS=1.75u PD=1.75u
M$83 \$9 \$I1743 \$7 \$I274 sg13_lv_pmos L=0.35u W=1.37u AS=0.2603p AD=0.2603p
+ PS=1.75u PD=1.75u
M$84 \$7 \$I1744 \$14 \$I274 sg13_lv_pmos L=0.35u W=1.37u AS=0.2603p AD=0.2603p
+ PS=1.75u PD=1.75u
M$85 \$14 \$I1695 \$13 \$I274 sg13_lv_pmos L=0.35u W=1.37u AS=0.2603p
+ AD=0.2603p PS=1.75u PD=1.75u
M$86 \$13 \$I1697 \$20 \$I274 sg13_lv_pmos L=0.35u W=1.37u AS=0.2603p
+ AD=0.2603p PS=1.75u PD=1.75u
M$87 \$20 \$I1762 \$19 \$I274 sg13_lv_pmos L=0.35u W=1.37u AS=0.2603p
+ AD=0.2603p PS=1.75u PD=1.75u
M$88 \$19 \$I1763 \$15 \$I274 sg13_lv_pmos L=0.35u W=1.37u AS=0.2603p
+ AD=0.2603p PS=1.75u PD=1.75u
M$89 \$15 \$I1764 \$8 \$I274 sg13_lv_pmos L=0.35u W=1.37u AS=0.2603p AD=0.2603p
+ PS=1.75u PD=1.75u
M$90 \$8 \$I1070 \$3 \$I274 sg13_lv_pmos L=0.35u W=1.37u AS=0.2603p AD=0.4658p
+ PS=1.75u PD=3.42u
M$91 \$2 \$I1095 \$1 \$I274 sg13_lv_pmos L=0.35u W=1.37u AS=0.4658p AD=0.2603p
+ PS=3.42u PD=1.75u
M$92 \$1 \$I870 \$9 \$I274 sg13_lv_pmos L=0.35u W=1.37u AS=0.2603p AD=0.2603p
+ PS=1.75u PD=1.75u
M$93 \$9 \$I1743 \$7 \$I274 sg13_lv_pmos L=0.35u W=1.37u AS=0.2603p AD=0.2603p
+ PS=1.75u PD=1.75u
M$94 \$7 \$I1744 \$14 \$I274 sg13_lv_pmos L=0.35u W=1.37u AS=0.2603p AD=0.2603p
+ PS=1.75u PD=1.75u
M$95 \$14 \$I1695 \$13 \$I274 sg13_lv_pmos L=0.35u W=1.37u AS=0.2603p
+ AD=0.2603p PS=1.75u PD=1.75u
M$96 \$13 \$I1697 \$20 \$I274 sg13_lv_pmos L=0.35u W=1.37u AS=0.2603p
+ AD=0.2603p PS=1.75u PD=1.75u
M$97 \$20 \$I1762 \$19 \$I274 sg13_lv_pmos L=0.35u W=1.37u AS=0.2603p
+ AD=0.2603p PS=1.75u PD=1.75u
M$98 \$19 \$I1763 \$15 \$I274 sg13_lv_pmos L=0.35u W=1.37u AS=0.2603p
+ AD=0.2603p PS=1.75u PD=1.75u
M$99 \$15 \$I1764 \$8 \$I274 sg13_lv_pmos L=0.35u W=1.37u AS=0.2603p AD=0.2603p
+ PS=1.75u PD=1.75u
M$100 \$8 \$I1070 \$3 \$I274 sg13_lv_pmos L=0.35u W=1.37u AS=0.2603p AD=0.4658p
+ PS=1.75u PD=3.42u
M$101 \$2 \$I1095 \$1 \$I274 sg13_lv_pmos L=0.35u W=1.37u AS=0.4658p AD=0.2603p
+ PS=3.42u PD=1.75u
M$102 \$1 \$I870 \$9 \$I274 sg13_lv_pmos L=0.35u W=1.37u AS=0.2603p AD=0.2603p
+ PS=1.75u PD=1.75u
M$103 \$9 \$I1743 \$7 \$I274 sg13_lv_pmos L=0.35u W=1.37u AS=0.2603p AD=0.2603p
+ PS=1.75u PD=1.75u
M$104 \$7 \$I1744 \$14 \$I274 sg13_lv_pmos L=0.35u W=1.37u AS=0.2603p
+ AD=0.2603p PS=1.75u PD=1.75u
M$105 \$14 \$I1695 \$13 \$I274 sg13_lv_pmos L=0.35u W=1.37u AS=0.2603p
+ AD=0.2603p PS=1.75u PD=1.75u
M$106 \$13 \$I1697 \$20 \$I274 sg13_lv_pmos L=0.35u W=1.37u AS=0.2603p
+ AD=0.2603p PS=1.75u PD=1.75u
M$107 \$20 \$I1762 \$19 \$I274 sg13_lv_pmos L=0.35u W=1.37u AS=0.2603p
+ AD=0.2603p PS=1.75u PD=1.75u
M$108 \$19 \$I1763 \$15 \$I274 sg13_lv_pmos L=0.35u W=1.37u AS=0.2603p
+ AD=0.2603p PS=1.75u PD=1.75u
M$109 \$15 \$I1764 \$8 \$I274 sg13_lv_pmos L=0.35u W=1.37u AS=0.2603p
+ AD=0.2603p PS=1.75u PD=1.75u
M$110 \$8 \$I1070 \$3 \$I274 sg13_lv_pmos L=0.35u W=1.37u AS=0.2603p AD=0.4658p
+ PS=1.75u PD=3.42u
M$111 \$2 \$I1095 \$1 \$I274 sg13_lv_pmos L=0.35u W=1.37u AS=0.4658p AD=0.2603p
+ PS=3.42u PD=1.75u
M$112 \$1 \$I870 \$9 \$I274 sg13_lv_pmos L=0.35u W=1.37u AS=0.2603p AD=0.2603p
+ PS=1.75u PD=1.75u
M$113 \$9 \$I1743 \$7 \$I274 sg13_lv_pmos L=0.35u W=1.37u AS=0.2603p AD=0.2603p
+ PS=1.75u PD=1.75u
M$114 \$7 \$I1744 \$14 \$I274 sg13_lv_pmos L=0.35u W=1.37u AS=0.2603p
+ AD=0.2603p PS=1.75u PD=1.75u
M$115 \$14 \$I1695 \$13 \$I274 sg13_lv_pmos L=0.35u W=1.37u AS=0.2603p
+ AD=0.2603p PS=1.75u PD=1.75u
M$116 \$13 \$I1697 \$20 \$I274 sg13_lv_pmos L=0.35u W=1.37u AS=0.2603p
+ AD=0.2603p PS=1.75u PD=1.75u
M$117 \$20 \$I1762 \$19 \$I274 sg13_lv_pmos L=0.35u W=1.37u AS=0.2603p
+ AD=0.2603p PS=1.75u PD=1.75u
M$118 \$19 \$I1763 \$15 \$I274 sg13_lv_pmos L=0.35u W=1.37u AS=0.2603p
+ AD=0.2603p PS=1.75u PD=1.75u
M$119 \$15 \$I1764 \$8 \$I274 sg13_lv_pmos L=0.35u W=1.37u AS=0.2603p
+ AD=0.2603p PS=1.75u PD=1.75u
M$120 \$8 \$I1070 \$3 \$I274 sg13_lv_pmos L=0.35u W=1.37u AS=0.2603p AD=0.4658p
+ PS=1.75u PD=3.42u
M$121 \$2 \$I1095 \$1 \$I274 sg13_lv_pmos L=0.35u W=1.37u AS=0.4658p AD=0.2603p
+ PS=3.42u PD=1.75u
M$122 \$1 \$I870 \$9 \$I274 sg13_lv_pmos L=0.35u W=1.37u AS=0.2603p AD=0.2603p
+ PS=1.75u PD=1.75u
M$123 \$9 \$I1743 \$7 \$I274 sg13_lv_pmos L=0.35u W=1.37u AS=0.2603p AD=0.2603p
+ PS=1.75u PD=1.75u
M$124 \$7 \$I1744 \$14 \$I274 sg13_lv_pmos L=0.35u W=1.37u AS=0.2603p
+ AD=0.2603p PS=1.75u PD=1.75u
M$125 \$14 \$I1695 \$13 \$I274 sg13_lv_pmos L=0.35u W=1.37u AS=0.2603p
+ AD=0.2603p PS=1.75u PD=1.75u
M$126 \$13 \$I1697 \$20 \$I274 sg13_lv_pmos L=0.35u W=1.37u AS=0.2603p
+ AD=0.2603p PS=1.75u PD=1.75u
M$127 \$20 \$I1762 \$19 \$I274 sg13_lv_pmos L=0.35u W=1.37u AS=0.2603p
+ AD=0.2603p PS=1.75u PD=1.75u
M$128 \$19 \$I1763 \$15 \$I274 sg13_lv_pmos L=0.35u W=1.37u AS=0.2603p
+ AD=0.2603p PS=1.75u PD=1.75u
M$129 \$15 \$I1764 \$8 \$I274 sg13_lv_pmos L=0.35u W=1.37u AS=0.2603p
+ AD=0.2603p PS=1.75u PD=1.75u
M$130 \$8 \$I1070 \$3 \$I274 sg13_lv_pmos L=0.35u W=1.37u AS=0.2603p AD=0.4658p
+ PS=1.75u PD=3.42u
M$131 \$2 \$I1095 \$1 \$I274 sg13_lv_pmos L=0.35u W=1.37u AS=0.4658p AD=0.2603p
+ PS=3.42u PD=1.75u
M$132 \$1 \$I870 \$9 \$I274 sg13_lv_pmos L=0.35u W=1.37u AS=0.2603p AD=0.2603p
+ PS=1.75u PD=1.75u
M$133 \$9 \$I1743 \$7 \$I274 sg13_lv_pmos L=0.35u W=1.37u AS=0.2603p AD=0.2603p
+ PS=1.75u PD=1.75u
M$134 \$7 \$I1744 \$14 \$I274 sg13_lv_pmos L=0.35u W=1.37u AS=0.2603p
+ AD=0.2603p PS=1.75u PD=1.75u
M$135 \$14 \$I1695 \$13 \$I274 sg13_lv_pmos L=0.35u W=1.37u AS=0.2603p
+ AD=0.2603p PS=1.75u PD=1.75u
M$136 \$13 \$I1697 \$20 \$I274 sg13_lv_pmos L=0.35u W=1.37u AS=0.2603p
+ AD=0.2603p PS=1.75u PD=1.75u
M$137 \$20 \$I1762 \$19 \$I274 sg13_lv_pmos L=0.35u W=1.37u AS=0.2603p
+ AD=0.2603p PS=1.75u PD=1.75u
M$138 \$19 \$I1763 \$15 \$I274 sg13_lv_pmos L=0.35u W=1.37u AS=0.2603p
+ AD=0.2603p PS=1.75u PD=1.75u
M$139 \$15 \$I1764 \$8 \$I274 sg13_lv_pmos L=0.35u W=1.37u AS=0.2603p
+ AD=0.2603p PS=1.75u PD=1.75u
M$140 \$8 \$I1070 \$3 \$I274 sg13_lv_pmos L=0.35u W=1.37u AS=0.2603p AD=0.4658p
+ PS=1.75u PD=3.42u
M$141 \$2 \$I1095 \$1 \$I274 sg13_lv_pmos L=0.35u W=1.37u AS=0.4658p AD=0.2603p
+ PS=3.42u PD=1.75u
M$142 \$1 \$I870 \$9 \$I274 sg13_lv_pmos L=0.35u W=1.37u AS=0.2603p AD=0.2603p
+ PS=1.75u PD=1.75u
M$143 \$9 \$I1743 \$7 \$I274 sg13_lv_pmos L=0.35u W=1.37u AS=0.2603p AD=0.2603p
+ PS=1.75u PD=1.75u
M$144 \$7 \$I1744 \$14 \$I274 sg13_lv_pmos L=0.35u W=1.37u AS=0.2603p
+ AD=0.2603p PS=1.75u PD=1.75u
M$145 \$14 \$I1695 \$13 \$I274 sg13_lv_pmos L=0.35u W=1.37u AS=0.2603p
+ AD=0.2603p PS=1.75u PD=1.75u
M$146 \$13 \$I1697 \$20 \$I274 sg13_lv_pmos L=0.35u W=1.37u AS=0.2603p
+ AD=0.2603p PS=1.75u PD=1.75u
M$147 \$20 \$I1762 \$19 \$I274 sg13_lv_pmos L=0.35u W=1.37u AS=0.2603p
+ AD=0.2603p PS=1.75u PD=1.75u
M$148 \$19 \$I1763 \$15 \$I274 sg13_lv_pmos L=0.35u W=1.37u AS=0.2603p
+ AD=0.2603p PS=1.75u PD=1.75u
M$149 \$15 \$I1764 \$8 \$I274 sg13_lv_pmos L=0.35u W=1.37u AS=0.2603p
+ AD=0.2603p PS=1.75u PD=1.75u
M$150 \$8 \$I1070 \$3 \$I274 sg13_lv_pmos L=0.35u W=1.37u AS=0.2603p AD=0.4658p
+ PS=1.75u PD=3.42u
M$151 \$2 \$I1095 \$1 \$I274 sg13_lv_pmos L=0.35u W=1.37u AS=0.4658p AD=0.2603p
+ PS=3.42u PD=1.75u
M$152 \$1 \$I870 \$9 \$I274 sg13_lv_pmos L=0.35u W=1.37u AS=0.2603p AD=0.2603p
+ PS=1.75u PD=1.75u
M$153 \$9 \$I1743 \$7 \$I274 sg13_lv_pmos L=0.35u W=1.37u AS=0.2603p AD=0.2603p
+ PS=1.75u PD=1.75u
M$154 \$7 \$I1744 \$14 \$I274 sg13_lv_pmos L=0.35u W=1.37u AS=0.2603p
+ AD=0.2603p PS=1.75u PD=1.75u
M$155 \$14 \$I1695 \$13 \$I274 sg13_lv_pmos L=0.35u W=1.37u AS=0.2603p
+ AD=0.2603p PS=1.75u PD=1.75u
M$156 \$13 \$I1697 \$20 \$I274 sg13_lv_pmos L=0.35u W=1.37u AS=0.2603p
+ AD=0.2603p PS=1.75u PD=1.75u
M$157 \$20 \$I1762 \$19 \$I274 sg13_lv_pmos L=0.35u W=1.37u AS=0.2603p
+ AD=0.2603p PS=1.75u PD=1.75u
M$158 \$19 \$I1763 \$15 \$I274 sg13_lv_pmos L=0.35u W=1.37u AS=0.2603p
+ AD=0.2603p PS=1.75u PD=1.75u
M$159 \$15 \$I1764 \$8 \$I274 sg13_lv_pmos L=0.35u W=1.37u AS=0.2603p
+ AD=0.2603p PS=1.75u PD=1.75u
M$160 \$8 \$I1070 \$3 \$I274 sg13_lv_pmos L=0.35u W=1.37u AS=0.2603p AD=0.4658p
+ PS=1.75u PD=3.42u
M$161 \$2 \$I1095 \$1 \$I274 sg13_lv_pmos L=0.35u W=1.37u AS=0.4658p AD=0.2603p
+ PS=3.42u PD=1.75u
M$162 \$1 \$I870 \$9 \$I274 sg13_lv_pmos L=0.35u W=1.37u AS=0.2603p AD=0.2603p
+ PS=1.75u PD=1.75u
M$163 \$9 \$I1743 \$7 \$I274 sg13_lv_pmos L=0.35u W=1.37u AS=0.2603p AD=0.2603p
+ PS=1.75u PD=1.75u
M$164 \$7 \$I1744 \$14 \$I274 sg13_lv_pmos L=0.35u W=1.37u AS=0.2603p
+ AD=0.2603p PS=1.75u PD=1.75u
M$165 \$14 \$I1695 \$13 \$I274 sg13_lv_pmos L=0.35u W=1.37u AS=0.2603p
+ AD=0.2603p PS=1.75u PD=1.75u
M$166 \$13 \$I1697 \$20 \$I274 sg13_lv_pmos L=0.35u W=1.37u AS=0.2603p
+ AD=0.2603p PS=1.75u PD=1.75u
M$167 \$20 \$I1762 \$19 \$I274 sg13_lv_pmos L=0.35u W=1.37u AS=0.2603p
+ AD=0.2603p PS=1.75u PD=1.75u
M$168 \$19 \$I1763 \$15 \$I274 sg13_lv_pmos L=0.35u W=1.37u AS=0.2603p
+ AD=0.2603p PS=1.75u PD=1.75u
M$169 \$15 \$I1764 \$8 \$I274 sg13_lv_pmos L=0.35u W=1.37u AS=0.2603p
+ AD=0.2603p PS=1.75u PD=1.75u
M$170 \$8 \$I1070 \$3 \$I274 sg13_lv_pmos L=0.35u W=1.37u AS=0.2603p AD=0.4658p
+ PS=1.75u PD=3.42u
M$171 \$2 \$I1095 \$1 \$I274 sg13_lv_pmos L=0.35u W=1.37u AS=0.4658p AD=0.2603p
+ PS=3.42u PD=1.75u
M$172 \$1 \$I870 \$9 \$I274 sg13_lv_pmos L=0.35u W=1.37u AS=0.2603p AD=0.2603p
+ PS=1.75u PD=1.75u
M$173 \$9 \$I1743 \$7 \$I274 sg13_lv_pmos L=0.35u W=1.37u AS=0.2603p AD=0.2603p
+ PS=1.75u PD=1.75u
M$174 \$7 \$I1744 \$14 \$I274 sg13_lv_pmos L=0.35u W=1.37u AS=0.2603p
+ AD=0.2603p PS=1.75u PD=1.75u
M$175 \$14 \$I1695 \$13 \$I274 sg13_lv_pmos L=0.35u W=1.37u AS=0.2603p
+ AD=0.2603p PS=1.75u PD=1.75u
M$176 \$13 \$I1697 \$20 \$I274 sg13_lv_pmos L=0.35u W=1.37u AS=0.2603p
+ AD=0.2603p PS=1.75u PD=1.75u
M$177 \$20 \$I1762 \$19 \$I274 sg13_lv_pmos L=0.35u W=1.37u AS=0.2603p
+ AD=0.2603p PS=1.75u PD=1.75u
M$178 \$19 \$I1763 \$15 \$I274 sg13_lv_pmos L=0.35u W=1.37u AS=0.2603p
+ AD=0.2603p PS=1.75u PD=1.75u
M$179 \$15 \$I1764 \$8 \$I274 sg13_lv_pmos L=0.35u W=1.37u AS=0.2603p
+ AD=0.2603p PS=1.75u PD=1.75u
M$180 \$8 \$I1070 \$3 \$I274 sg13_lv_pmos L=0.35u W=1.37u AS=0.2603p AD=0.4658p
+ PS=1.75u PD=3.42u
M$181 \$2 \$I1095 \$1 \$I274 sg13_lv_pmos L=0.35u W=1.37u AS=0.4658p AD=0.2603p
+ PS=3.42u PD=1.75u
M$182 \$1 \$I870 \$9 \$I274 sg13_lv_pmos L=0.35u W=1.37u AS=0.2603p AD=0.2603p
+ PS=1.75u PD=1.75u
M$183 \$9 \$I1743 \$7 \$I274 sg13_lv_pmos L=0.35u W=1.37u AS=0.2603p AD=0.2603p
+ PS=1.75u PD=1.75u
M$184 \$7 \$I1744 \$14 \$I274 sg13_lv_pmos L=0.35u W=1.37u AS=0.2603p
+ AD=0.2603p PS=1.75u PD=1.75u
M$185 \$14 \$I1695 \$13 \$I274 sg13_lv_pmos L=0.35u W=1.37u AS=0.2603p
+ AD=0.2603p PS=1.75u PD=1.75u
M$186 \$13 \$I1697 \$20 \$I274 sg13_lv_pmos L=0.35u W=1.37u AS=0.2603p
+ AD=0.2603p PS=1.75u PD=1.75u
M$187 \$20 \$I1762 \$19 \$I274 sg13_lv_pmos L=0.35u W=1.37u AS=0.2603p
+ AD=0.2603p PS=1.75u PD=1.75u
M$188 \$19 \$I1763 \$15 \$I274 sg13_lv_pmos L=0.35u W=1.37u AS=0.2603p
+ AD=0.2603p PS=1.75u PD=1.75u
M$189 \$15 \$I1764 \$8 \$I274 sg13_lv_pmos L=0.35u W=1.37u AS=0.2603p
+ AD=0.2603p PS=1.75u PD=1.75u
M$190 \$8 \$I1070 \$3 \$I274 sg13_lv_pmos L=0.35u W=1.37u AS=0.2603p AD=0.4658p
+ PS=1.75u PD=3.42u
M$191 \$2 \$I1095 \$1 \$I274 sg13_lv_pmos L=0.35u W=1.37u AS=0.4658p AD=0.2603p
+ PS=3.42u PD=1.75u
M$192 \$1 \$I870 \$9 \$I274 sg13_lv_pmos L=0.35u W=1.37u AS=0.2603p AD=0.2603p
+ PS=1.75u PD=1.75u
M$193 \$9 \$I1743 \$7 \$I274 sg13_lv_pmos L=0.35u W=1.37u AS=0.2603p AD=0.2603p
+ PS=1.75u PD=1.75u
M$194 \$7 \$I1744 \$14 \$I274 sg13_lv_pmos L=0.35u W=1.37u AS=0.2603p
+ AD=0.2603p PS=1.75u PD=1.75u
M$195 \$14 \$I1695 \$13 \$I274 sg13_lv_pmos L=0.35u W=1.37u AS=0.2603p
+ AD=0.2603p PS=1.75u PD=1.75u
M$196 \$13 \$I1697 \$20 \$I274 sg13_lv_pmos L=0.35u W=1.37u AS=0.2603p
+ AD=0.2603p PS=1.75u PD=1.75u
M$197 \$20 \$I1762 \$19 \$I274 sg13_lv_pmos L=0.35u W=1.37u AS=0.2603p
+ AD=0.2603p PS=1.75u PD=1.75u
M$198 \$19 \$I1763 \$15 \$I274 sg13_lv_pmos L=0.35u W=1.37u AS=0.2603p
+ AD=0.2603p PS=1.75u PD=1.75u
M$199 \$15 \$I1764 \$8 \$I274 sg13_lv_pmos L=0.35u W=1.37u AS=0.2603p
+ AD=0.2603p PS=1.75u PD=1.75u
M$200 \$8 \$I1070 \$3 \$I274 sg13_lv_pmos L=0.35u W=1.37u AS=0.2603p AD=0.4658p
+ PS=1.75u PD=3.42u
M$201 \$2 \$I1095 \$1 \$I274 sg13_lv_pmos L=0.35u W=1.37u AS=0.4658p AD=0.2603p
+ PS=3.42u PD=1.75u
M$202 \$1 \$I870 \$9 \$I274 sg13_lv_pmos L=0.35u W=1.37u AS=0.2603p AD=0.2603p
+ PS=1.75u PD=1.75u
M$203 \$9 \$I1743 \$7 \$I274 sg13_lv_pmos L=0.35u W=1.37u AS=0.2603p AD=0.2603p
+ PS=1.75u PD=1.75u
M$204 \$7 \$I1744 \$14 \$I274 sg13_lv_pmos L=0.35u W=1.37u AS=0.2603p
+ AD=0.2603p PS=1.75u PD=1.75u
M$205 \$14 \$I1695 \$13 \$I274 sg13_lv_pmos L=0.35u W=1.37u AS=0.2603p
+ AD=0.2603p PS=1.75u PD=1.75u
M$206 \$13 \$I1697 \$20 \$I274 sg13_lv_pmos L=0.35u W=1.37u AS=0.2603p
+ AD=0.2603p PS=1.75u PD=1.75u
M$207 \$20 \$I1762 \$19 \$I274 sg13_lv_pmos L=0.35u W=1.37u AS=0.2603p
+ AD=0.2603p PS=1.75u PD=1.75u
M$208 \$19 \$I1763 \$15 \$I274 sg13_lv_pmos L=0.35u W=1.37u AS=0.2603p
+ AD=0.2603p PS=1.75u PD=1.75u
M$209 \$15 \$I1764 \$8 \$I274 sg13_lv_pmos L=0.35u W=1.37u AS=0.2603p
+ AD=0.2603p PS=1.75u PD=1.75u
M$210 \$8 \$I1070 \$3 \$I274 sg13_lv_pmos L=0.35u W=1.37u AS=0.2603p AD=0.4658p
+ PS=1.75u PD=3.42u
M$211 \$2 \$I1095 \$1 \$I274 sg13_lv_pmos L=0.35u W=1.37u AS=0.4658p AD=0.2603p
+ PS=3.42u PD=1.75u
M$212 \$1 \$I870 \$9 \$I274 sg13_lv_pmos L=0.35u W=1.37u AS=0.2603p AD=0.2603p
+ PS=1.75u PD=1.75u
M$213 \$9 \$I1743 \$7 \$I274 sg13_lv_pmos L=0.35u W=1.37u AS=0.2603p AD=0.2603p
+ PS=1.75u PD=1.75u
M$214 \$7 \$I1744 \$14 \$I274 sg13_lv_pmos L=0.35u W=1.37u AS=0.2603p
+ AD=0.2603p PS=1.75u PD=1.75u
M$215 \$14 \$I1695 \$13 \$I274 sg13_lv_pmos L=0.35u W=1.37u AS=0.2603p
+ AD=0.2603p PS=1.75u PD=1.75u
M$216 \$13 \$I1697 \$20 \$I274 sg13_lv_pmos L=0.35u W=1.37u AS=0.2603p
+ AD=0.2603p PS=1.75u PD=1.75u
M$217 \$20 \$I1762 \$19 \$I274 sg13_lv_pmos L=0.35u W=1.37u AS=0.2603p
+ AD=0.2603p PS=1.75u PD=1.75u
M$218 \$19 \$I1763 \$15 \$I274 sg13_lv_pmos L=0.35u W=1.37u AS=0.2603p
+ AD=0.2603p PS=1.75u PD=1.75u
M$219 \$15 \$I1764 \$8 \$I274 sg13_lv_pmos L=0.35u W=1.37u AS=0.2603p
+ AD=0.2603p PS=1.75u PD=1.75u
M$220 \$8 \$I1070 \$3 \$I274 sg13_lv_pmos L=0.35u W=1.37u AS=0.2603p AD=0.4658p
+ PS=1.75u PD=3.42u
M$221 \$2 \$I1095 \$1 \$I274 sg13_lv_pmos L=0.35u W=1.37u AS=0.4658p AD=0.2603p
+ PS=3.42u PD=1.75u
M$222 \$1 \$I870 \$9 \$I274 sg13_lv_pmos L=0.35u W=1.37u AS=0.2603p AD=0.2603p
+ PS=1.75u PD=1.75u
M$223 \$9 \$I1743 \$7 \$I274 sg13_lv_pmos L=0.35u W=1.37u AS=0.2603p AD=0.2603p
+ PS=1.75u PD=1.75u
M$224 \$7 \$I1744 \$14 \$I274 sg13_lv_pmos L=0.35u W=1.37u AS=0.2603p
+ AD=0.2603p PS=1.75u PD=1.75u
M$225 \$14 \$I1695 \$13 \$I274 sg13_lv_pmos L=0.35u W=1.37u AS=0.2603p
+ AD=0.2603p PS=1.75u PD=1.75u
M$226 \$13 \$I1697 \$20 \$I274 sg13_lv_pmos L=0.35u W=1.37u AS=0.2603p
+ AD=0.2603p PS=1.75u PD=1.75u
M$227 \$20 \$I1762 \$19 \$I274 sg13_lv_pmos L=0.35u W=1.37u AS=0.2603p
+ AD=0.2603p PS=1.75u PD=1.75u
M$228 \$19 \$I1763 \$15 \$I274 sg13_lv_pmos L=0.35u W=1.37u AS=0.2603p
+ AD=0.2603p PS=1.75u PD=1.75u
M$229 \$15 \$I1764 \$8 \$I274 sg13_lv_pmos L=0.35u W=1.37u AS=0.2603p
+ AD=0.2603p PS=1.75u PD=1.75u
M$230 \$8 \$I1070 \$3 \$I274 sg13_lv_pmos L=0.35u W=1.37u AS=0.2603p AD=0.4658p
+ PS=1.75u PD=3.42u
M$231 \$2 \$I1095 \$1 \$I274 sg13_lv_pmos L=0.35u W=1.37u AS=0.4658p AD=0.2603p
+ PS=3.42u PD=1.75u
M$232 \$1 \$I870 \$9 \$I274 sg13_lv_pmos L=0.35u W=1.37u AS=0.2603p AD=0.2603p
+ PS=1.75u PD=1.75u
M$233 \$9 \$I1743 \$7 \$I274 sg13_lv_pmos L=0.35u W=1.37u AS=0.2603p AD=0.2603p
+ PS=1.75u PD=1.75u
M$234 \$7 \$I1744 \$14 \$I274 sg13_lv_pmos L=0.35u W=1.37u AS=0.2603p
+ AD=0.2603p PS=1.75u PD=1.75u
M$235 \$14 \$I1695 \$13 \$I274 sg13_lv_pmos L=0.35u W=1.37u AS=0.2603p
+ AD=0.2603p PS=1.75u PD=1.75u
M$236 \$13 \$I1697 \$20 \$I274 sg13_lv_pmos L=0.35u W=1.37u AS=0.2603p
+ AD=0.2603p PS=1.75u PD=1.75u
M$237 \$20 \$I1762 \$19 \$I274 sg13_lv_pmos L=0.35u W=1.37u AS=0.2603p
+ AD=0.2603p PS=1.75u PD=1.75u
M$238 \$19 \$I1763 \$15 \$I274 sg13_lv_pmos L=0.35u W=1.37u AS=0.2603p
+ AD=0.2603p PS=1.75u PD=1.75u
M$239 \$15 \$I1764 \$8 \$I274 sg13_lv_pmos L=0.35u W=1.37u AS=0.2603p
+ AD=0.2603p PS=1.75u PD=1.75u
M$240 \$8 \$I1070 \$3 \$I274 sg13_lv_pmos L=0.35u W=1.37u AS=0.2603p AD=0.4658p
+ PS=1.75u PD=3.42u
M$241 \$2 \$I1095 \$1 \$I274 sg13_lv_pmos L=0.35u W=1.37u AS=0.4658p AD=0.2603p
+ PS=3.42u PD=1.75u
M$242 \$1 \$I870 \$9 \$I274 sg13_lv_pmos L=0.35u W=1.37u AS=0.2603p AD=0.2603p
+ PS=1.75u PD=1.75u
M$243 \$9 \$I1743 \$7 \$I274 sg13_lv_pmos L=0.35u W=1.37u AS=0.2603p AD=0.2603p
+ PS=1.75u PD=1.75u
M$244 \$7 \$I1744 \$14 \$I274 sg13_lv_pmos L=0.35u W=1.37u AS=0.2603p
+ AD=0.2603p PS=1.75u PD=1.75u
M$245 \$14 \$I1695 \$13 \$I274 sg13_lv_pmos L=0.35u W=1.37u AS=0.2603p
+ AD=0.2603p PS=1.75u PD=1.75u
M$246 \$13 \$I1697 \$20 \$I274 sg13_lv_pmos L=0.35u W=1.37u AS=0.2603p
+ AD=0.2603p PS=1.75u PD=1.75u
M$247 \$20 \$I1762 \$19 \$I274 sg13_lv_pmos L=0.35u W=1.37u AS=0.2603p
+ AD=0.2603p PS=1.75u PD=1.75u
M$248 \$19 \$I1763 \$15 \$I274 sg13_lv_pmos L=0.35u W=1.37u AS=0.2603p
+ AD=0.2603p PS=1.75u PD=1.75u
M$249 \$15 \$I1764 \$8 \$I274 sg13_lv_pmos L=0.35u W=1.37u AS=0.2603p
+ AD=0.2603p PS=1.75u PD=1.75u
M$250 \$8 \$I1070 \$3 \$I274 sg13_lv_pmos L=0.35u W=1.37u AS=0.2603p AD=0.4658p
+ PS=1.75u PD=3.42u
.ENDS M9M10$1

.SUBCKT sourceRowM5M6$1 \$1 \$2
X$1 \$1 \$2 via_stack$1
X$2 \$1 \$2 via_stack$1
X$3 \$1 \$2 via_stack$1
.ENDS sourceRowM5M6$1

.SUBCKT gateM5M6$1 \$1 \$2
X$1 \$2 \$1 via_stack$8
.ENDS gateM5M6$1

.SUBCKT drainRowM5M6$1 \$1 \$2
X$1 \$1 \$2 via_stack$1
X$2 \$1 \$2 via_stack$1
X$3 \$1 \$2 via_stack$1
X$4 \$1 \$2 via_stack$1
.ENDS drainRowM5M6$1

.SUBCKT M5M6$1 \$1 \$2 \$3 \$5 \$7 \$13 \$17 \$36 \$I210 \$I205 \$I200 \$I195
+ \$I190 \$I186 \$I185
X$1 \$36 \$1 M1_conM5M6$1
X$2 \$1 \$13 \$I185 \$36 \$I190 pmos$2
X$3 \$1 \$13 \$I185 \$36 \$I190 pmos$2
X$4 \$17 \$1 \$I185 \$36 \$I186 pmos$2
X$5 \$17 \$1 \$I185 \$36 \$I186 pmos$2
X$6 \$36 \$1 M1_conM5M6$1
X$7 \$1 \$13 \$I185 \$36 \$I190 pmos$2
X$8 \$17 \$1 \$I185 \$36 \$I186 pmos$2
X$9 \$36 \$1 M1_conM5M6$1
X$10 \$1 \$13 \$I185 \$36 \$I190 pmos$2
X$11 \$17 \$1 \$I185 \$36 \$I186 pmos$2
X$12 \$36 \$1 M1_conM5M6$1
X$13 \$1 \$13 \$I185 \$36 \$I190 pmos$2
X$14 \$17 \$1 \$I185 \$36 \$I186 pmos$2
X$15 \$36 \$2 M1_conM5M6$1
X$16 \$2 \$7 \$I185 \$36 \$I210 pmos$2
X$17 \$2 \$7 \$I185 \$36 \$I210 pmos$2
X$18 \$3 \$2 \$I185 \$36 \$I205 pmos$2
X$19 \$3 \$2 \$I185 \$36 \$I205 pmos$2
X$20 \$36 \$2 M1_conM5M6$1
X$21 \$2 \$7 \$I185 \$36 \$I210 pmos$2
X$22 \$3 \$2 \$I185 \$36 \$I205 pmos$2
X$23 \$36 \$2 M1_conM5M6$1
X$24 \$2 \$7 \$I185 \$36 \$I210 pmos$2
X$25 \$3 \$2 \$I185 \$36 \$I205 pmos$2
X$26 \$36 \$2 M1_conM5M6$1
X$27 \$2 \$7 \$I185 \$36 \$I210 pmos$2
X$28 \$3 \$2 \$I185 \$36 \$I205 pmos$2
X$29 \$36 \$3 M1_conM5M6$1
X$30 \$5 \$3 \$I185 \$36 \$I200 pmos$2
X$31 \$5 \$3 \$I185 \$36 \$I200 pmos$2
X$32 \$36 \$3 M1_conM5M6$1
X$33 \$5 \$3 \$I185 \$36 \$I200 pmos$2
X$34 \$36 \$3 M1_conM5M6$1
X$35 \$5 \$3 \$I185 \$36 \$I200 pmos$2
X$36 \$36 \$3 M1_conM5M6$1
X$37 \$5 \$3 \$I185 \$36 \$I200 pmos$2
X$38 \$36 \$5 M1_conM5M6$1
X$39 \$13 \$5 \$I185 \$36 \$I195 pmos$2
X$40 \$13 \$5 \$I185 \$36 \$I195 pmos$2
X$41 \$36 \$5 M1_conM5M6$1
X$42 \$13 \$5 \$I185 \$36 \$I195 pmos$2
X$43 \$36 \$5 M1_conM5M6$1
X$44 \$13 \$5 \$I185 \$36 \$I195 pmos$2
X$45 \$36 \$5 M1_conM5M6$1
X$46 \$13 \$5 \$I185 \$36 \$I195 pmos$2
X$47 \$36 \$7 M1_conM5M6$1
X$48 \$36 \$7 M1_conM5M6$1
X$49 \$36 \$7 M1_conM5M6$1
X$50 \$36 \$7 M1_conM5M6$1
X$51 \$36 \$13 M1_conM5M6$1
X$52 \$36 \$13 M1_conM5M6$1
X$53 \$36 \$13 M1_conM5M6$1
X$54 \$36 \$13 M1_conM5M6$1
X$55 \$36 \$17 M1_conM5M6$1
X$56 \$36 \$17 M1_conM5M6$1
X$57 \$36 \$17 M1_conM5M6$1
X$58 \$36 \$17 M1_conM5M6$1
M$1 \$17 \$I186 \$1 \$I185 sg13_lv_pmos L=0.5u W=4.05u AS=1.377p AD=0.7695p
+ PS=8.78u PD=4.43u
M$2 \$1 \$I190 \$13 \$I185 sg13_lv_pmos L=0.5u W=4.05u AS=0.7695p AD=0.7695p
+ PS=4.43u PD=4.43u
M$3 \$13 \$I195 \$5 \$I185 sg13_lv_pmos L=0.5u W=4.05u AS=0.7695p AD=0.7695p
+ PS=4.43u PD=4.43u
M$4 \$5 \$I200 \$3 \$I185 sg13_lv_pmos L=0.5u W=4.05u AS=0.7695p AD=0.7695p
+ PS=4.43u PD=4.43u
M$5 \$3 \$I205 \$2 \$I185 sg13_lv_pmos L=0.5u W=4.05u AS=0.7695p AD=0.7695p
+ PS=4.43u PD=4.43u
M$6 \$2 \$I210 \$7 \$I185 sg13_lv_pmos L=0.5u W=4.05u AS=0.7695p AD=1.377p
+ PS=4.43u PD=8.78u
M$7 \$17 \$I186 \$1 \$I185 sg13_lv_pmos L=0.5u W=4.05u AS=1.377p AD=0.7695p
+ PS=8.78u PD=4.43u
M$8 \$1 \$I190 \$13 \$I185 sg13_lv_pmos L=0.5u W=4.05u AS=0.7695p AD=0.7695p
+ PS=4.43u PD=4.43u
M$9 \$13 \$I195 \$5 \$I185 sg13_lv_pmos L=0.5u W=4.05u AS=0.7695p AD=0.7695p
+ PS=4.43u PD=4.43u
M$10 \$5 \$I200 \$3 \$I185 sg13_lv_pmos L=0.5u W=4.05u AS=0.7695p AD=0.7695p
+ PS=4.43u PD=4.43u
M$11 \$3 \$I205 \$2 \$I185 sg13_lv_pmos L=0.5u W=4.05u AS=0.7695p AD=0.7695p
+ PS=4.43u PD=4.43u
M$12 \$2 \$I210 \$7 \$I185 sg13_lv_pmos L=0.5u W=4.05u AS=0.7695p AD=1.377p
+ PS=4.43u PD=8.78u
M$13 \$17 \$I186 \$1 \$I185 sg13_lv_pmos L=0.5u W=4.05u AS=1.377p AD=0.7695p
+ PS=8.78u PD=4.43u
M$14 \$1 \$I190 \$13 \$I185 sg13_lv_pmos L=0.5u W=4.05u AS=0.7695p AD=0.7695p
+ PS=4.43u PD=4.43u
M$15 \$13 \$I195 \$5 \$I185 sg13_lv_pmos L=0.5u W=4.05u AS=0.7695p AD=0.7695p
+ PS=4.43u PD=4.43u
M$16 \$5 \$I200 \$3 \$I185 sg13_lv_pmos L=0.5u W=4.05u AS=0.7695p AD=0.7695p
+ PS=4.43u PD=4.43u
M$17 \$3 \$I205 \$2 \$I185 sg13_lv_pmos L=0.5u W=4.05u AS=0.7695p AD=0.7695p
+ PS=4.43u PD=4.43u
M$18 \$2 \$I210 \$7 \$I185 sg13_lv_pmos L=0.5u W=4.05u AS=0.7695p AD=1.377p
+ PS=4.43u PD=8.78u
M$19 \$17 \$I186 \$1 \$I185 sg13_lv_pmos L=0.5u W=4.05u AS=1.377p AD=0.7695p
+ PS=8.78u PD=4.43u
M$20 \$1 \$I190 \$13 \$I185 sg13_lv_pmos L=0.5u W=4.05u AS=0.7695p AD=0.7695p
+ PS=4.43u PD=4.43u
M$21 \$13 \$I195 \$5 \$I185 sg13_lv_pmos L=0.5u W=4.05u AS=0.7695p AD=0.7695p
+ PS=4.43u PD=4.43u
M$22 \$5 \$I200 \$3 \$I185 sg13_lv_pmos L=0.5u W=4.05u AS=0.7695p AD=0.7695p
+ PS=4.43u PD=4.43u
M$23 \$3 \$I205 \$2 \$I185 sg13_lv_pmos L=0.5u W=4.05u AS=0.7695p AD=0.7695p
+ PS=4.43u PD=4.43u
M$24 \$2 \$I210 \$7 \$I185 sg13_lv_pmos L=0.5u W=4.05u AS=0.7695p AD=1.377p
+ PS=4.43u PD=8.78u
M$25 \$17 \$I186 \$1 \$I185 sg13_lv_pmos L=0.5u W=4.05u AS=1.377p AD=0.7695p
+ PS=8.78u PD=4.43u
M$26 \$1 \$I190 \$13 \$I185 sg13_lv_pmos L=0.5u W=4.05u AS=0.7695p AD=0.7695p
+ PS=4.43u PD=4.43u
M$27 \$13 \$I195 \$5 \$I185 sg13_lv_pmos L=0.5u W=4.05u AS=0.7695p AD=0.7695p
+ PS=4.43u PD=4.43u
M$28 \$5 \$I200 \$3 \$I185 sg13_lv_pmos L=0.5u W=4.05u AS=0.7695p AD=0.7695p
+ PS=4.43u PD=4.43u
M$29 \$3 \$I205 \$2 \$I185 sg13_lv_pmos L=0.5u W=4.05u AS=0.7695p AD=0.7695p
+ PS=4.43u PD=4.43u
M$30 \$2 \$I210 \$7 \$I185 sg13_lv_pmos L=0.5u W=4.05u AS=0.7695p AD=1.377p
+ PS=4.43u PD=8.78u
.ENDS M5M6$1

.SUBCKT sourceRowM7M8$1 \$1 \$2
X$1 \$1 \$2 via_stack$1
X$2 \$1 \$2 via_stack$1
X$3 \$1 \$2 via_stack$1
.ENDS sourceRowM7M8$1

.SUBCKT gateM7M8$1 \$1 \$2
X$1 \$2 \$1 via_stack$9
.ENDS gateM7M8$1

.SUBCKT drainRowM7M8$1 \$1 \$2
X$1 \$1 \$2 via_stack$1
X$2 \$1 \$2 via_stack$1
X$3 \$1 \$2 via_stack$1
X$4 \$1 \$2 via_stack$1
.ENDS drainRowM7M8$1

.SUBCKT M7M8$1 \$1 \$3 \$4 \$5 \$7 \$12 \$15 \$36 \$I210 \$I205 \$I200 \$I195
+ \$I190 \$I186 \$I185
X$1 \$1 \$12 \$I185 \$36 \$I205 pmos$3
X$2 \$36 \$1 M1_conM7M8$1
X$3 \$1 \$12 \$I185 \$36 \$I205 pmos$3
X$4 \$36 \$1 M1_conM7M8$1
X$5 \$1 \$12 \$I185 \$36 \$I205 pmos$3
X$6 \$36 \$1 M1_conM7M8$1
X$7 \$1 \$12 \$I185 \$36 \$I205 pmos$3
X$8 \$36 \$1 M1_conM7M8$1
X$9 \$1 \$12 \$I185 \$36 \$I205 pmos$3
X$10 \$3 \$1 \$I185 \$36 \$I200 pmos$3
X$11 \$3 \$1 \$I185 \$36 \$I200 pmos$3
X$12 \$3 \$1 \$I185 \$36 \$I200 pmos$3
X$13 \$3 \$1 \$I185 \$36 \$I200 pmos$3
X$14 \$3 \$1 \$I185 \$36 \$I200 pmos$3
X$15 \$36 \$3 M1_conM7M8$1
X$16 \$36 \$3 M1_conM7M8$1
X$17 \$36 \$3 M1_conM7M8$1
X$18 \$36 \$3 M1_conM7M8$1
X$19 \$4 \$3 \$I185 \$36 \$I195 pmos$3
X$20 \$4 \$3 \$I185 \$36 \$I195 pmos$3
X$21 \$4 \$3 \$I185 \$36 \$I195 pmos$3
X$22 \$4 \$3 \$I185 \$36 \$I195 pmos$3
X$23 \$4 \$3 \$I185 \$36 \$I195 pmos$3
X$24 \$36 \$4 M1_conM7M8$1
X$25 \$36 \$4 M1_conM7M8$1
X$26 \$36 \$4 M1_conM7M8$1
X$27 \$36 \$4 M1_conM7M8$1
X$28 \$5 \$4 \$I185 \$36 \$I190 pmos$3
X$29 \$5 \$4 \$I185 \$36 \$I190 pmos$3
X$30 \$5 \$4 \$I185 \$36 \$I190 pmos$3
X$31 \$5 \$4 \$I185 \$36 \$I190 pmos$3
X$32 \$5 \$4 \$I185 \$36 \$I190 pmos$3
X$33 \$36 \$5 M1_conM7M8$1
X$34 \$36 \$5 M1_conM7M8$1
X$35 \$36 \$5 M1_conM7M8$1
X$36 \$36 \$5 M1_conM7M8$1
X$37 \$15 \$5 \$I185 \$36 \$I186 pmos$3
X$38 \$15 \$5 \$I185 \$36 \$I186 pmos$3
X$39 \$15 \$5 \$I185 \$36 \$I186 pmos$3
X$40 \$15 \$5 \$I185 \$36 \$I186 pmos$3
X$41 \$15 \$5 \$I185 \$36 \$I186 pmos$3
X$42 \$12 \$7 \$I185 \$36 \$I210 pmos$3
X$43 \$36 \$7 M1_conM7M8$1
X$44 \$12 \$7 \$I185 \$36 \$I210 pmos$3
X$45 \$36 \$7 M1_conM7M8$1
X$46 \$12 \$7 \$I185 \$36 \$I210 pmos$3
X$47 \$36 \$7 M1_conM7M8$1
X$48 \$12 \$7 \$I185 \$36 \$I210 pmos$3
X$49 \$36 \$7 M1_conM7M8$1
X$50 \$12 \$7 \$I185 \$36 \$I210 pmos$3
X$51 \$36 \$12 M1_conM7M8$1
X$52 \$36 \$12 M1_conM7M8$1
X$53 \$36 \$12 M1_conM7M8$1
X$54 \$36 \$12 M1_conM7M8$1
X$55 \$36 \$15 M1_conM7M8$1
X$56 \$36 \$15 M1_conM7M8$1
X$57 \$36 \$15 M1_conM7M8$1
X$58 \$36 \$15 M1_conM7M8$1
M$1 \$15 \$I186 \$5 \$I185 sg13_lv_pmos L=0.7u W=7u AS=2.38p AD=1.33p PS=14.68u
+ PD=7.38u
M$2 \$5 \$I190 \$4 \$I185 sg13_lv_pmos L=0.7u W=7u AS=1.33p AD=1.33p PS=7.38u
+ PD=7.38u
M$3 \$4 \$I195 \$3 \$I185 sg13_lv_pmos L=0.7u W=7u AS=1.33p AD=1.33p PS=7.38u
+ PD=7.38u
M$4 \$3 \$I200 \$1 \$I185 sg13_lv_pmos L=0.7u W=7u AS=1.33p AD=1.33p PS=7.38u
+ PD=7.38u
M$5 \$1 \$I205 \$12 \$I185 sg13_lv_pmos L=0.7u W=7u AS=1.33p AD=1.33p PS=7.38u
+ PD=7.38u
M$6 \$12 \$I210 \$7 \$I185 sg13_lv_pmos L=0.7u W=7u AS=1.33p AD=2.38p PS=7.38u
+ PD=14.68u
M$7 \$15 \$I186 \$5 \$I185 sg13_lv_pmos L=0.7u W=7u AS=2.38p AD=1.33p PS=14.68u
+ PD=7.38u
M$8 \$5 \$I190 \$4 \$I185 sg13_lv_pmos L=0.7u W=7u AS=1.33p AD=1.33p PS=7.38u
+ PD=7.38u
M$9 \$4 \$I195 \$3 \$I185 sg13_lv_pmos L=0.7u W=7u AS=1.33p AD=1.33p PS=7.38u
+ PD=7.38u
M$10 \$3 \$I200 \$1 \$I185 sg13_lv_pmos L=0.7u W=7u AS=1.33p AD=1.33p PS=7.38u
+ PD=7.38u
M$11 \$1 \$I205 \$12 \$I185 sg13_lv_pmos L=0.7u W=7u AS=1.33p AD=1.33p PS=7.38u
+ PD=7.38u
M$12 \$12 \$I210 \$7 \$I185 sg13_lv_pmos L=0.7u W=7u AS=1.33p AD=2.38p PS=7.38u
+ PD=14.68u
M$13 \$15 \$I186 \$5 \$I185 sg13_lv_pmos L=0.7u W=7u AS=2.38p AD=1.33p
+ PS=14.68u PD=7.38u
M$14 \$5 \$I190 \$4 \$I185 sg13_lv_pmos L=0.7u W=7u AS=1.33p AD=1.33p PS=7.38u
+ PD=7.38u
M$15 \$4 \$I195 \$3 \$I185 sg13_lv_pmos L=0.7u W=7u AS=1.33p AD=1.33p PS=7.38u
+ PD=7.38u
M$16 \$3 \$I200 \$1 \$I185 sg13_lv_pmos L=0.7u W=7u AS=1.33p AD=1.33p PS=7.38u
+ PD=7.38u
M$17 \$1 \$I205 \$12 \$I185 sg13_lv_pmos L=0.7u W=7u AS=1.33p AD=1.33p PS=7.38u
+ PD=7.38u
M$18 \$12 \$I210 \$7 \$I185 sg13_lv_pmos L=0.7u W=7u AS=1.33p AD=2.38p PS=7.38u
+ PD=14.68u
M$19 \$15 \$I186 \$5 \$I185 sg13_lv_pmos L=0.7u W=7u AS=2.38p AD=1.33p
+ PS=14.68u PD=7.38u
M$20 \$5 \$I190 \$4 \$I185 sg13_lv_pmos L=0.7u W=7u AS=1.33p AD=1.33p PS=7.38u
+ PD=7.38u
M$21 \$4 \$I195 \$3 \$I185 sg13_lv_pmos L=0.7u W=7u AS=1.33p AD=1.33p PS=7.38u
+ PD=7.38u
M$22 \$3 \$I200 \$1 \$I185 sg13_lv_pmos L=0.7u W=7u AS=1.33p AD=1.33p PS=7.38u
+ PD=7.38u
M$23 \$1 \$I205 \$12 \$I185 sg13_lv_pmos L=0.7u W=7u AS=1.33p AD=1.33p PS=7.38u
+ PD=7.38u
M$24 \$12 \$I210 \$7 \$I185 sg13_lv_pmos L=0.7u W=7u AS=1.33p AD=2.38p PS=7.38u
+ PD=14.68u
M$25 \$15 \$I186 \$5 \$I185 sg13_lv_pmos L=0.7u W=7u AS=2.38p AD=1.33p
+ PS=14.68u PD=7.38u
M$26 \$5 \$I190 \$4 \$I185 sg13_lv_pmos L=0.7u W=7u AS=1.33p AD=1.33p PS=7.38u
+ PD=7.38u
M$27 \$4 \$I195 \$3 \$I185 sg13_lv_pmos L=0.7u W=7u AS=1.33p AD=1.33p PS=7.38u
+ PD=7.38u
M$28 \$3 \$I200 \$1 \$I185 sg13_lv_pmos L=0.7u W=7u AS=1.33p AD=1.33p PS=7.38u
+ PD=7.38u
M$29 \$1 \$I205 \$12 \$I185 sg13_lv_pmos L=0.7u W=7u AS=1.33p AD=1.33p PS=7.38u
+ PD=7.38u
M$30 \$12 \$I210 \$7 \$I185 sg13_lv_pmos L=0.7u W=7u AS=1.33p AD=2.38p PS=7.38u
+ PD=14.68u
.ENDS M7M8$1

.SUBCKT gateM1M2$1 \$1 \$2
X$1 \$2 \$1 via_stack$10
.ENDS gateM1M2$1

.SUBCKT sourceRowM1M2$1 \$1 \$2
X$1 \$2 \$1 via_stack$1
X$2 \$2 \$1 via_stack$1
X$3 \$2 \$1 via_stack$1
.ENDS sourceRowM1M2$1

.SUBCKT drainRowM1M2$1 \$1 \$2
X$1 \$2 \$1 via_stack$1
X$2 \$2 \$1 via_stack$1
X$3 \$2 \$1 via_stack$1
X$4 \$2 \$1 via_stack$1
.ENDS drainRowM1M2$1

.SUBCKT M1M2$1 \$1 \$2 \$3 \$5 \$6 \$7 \$9 \$12 \$I180 \$I175 \$I170 \$I165
+ \$I160 \$I156
X$1 \$5 \$3 \$1 \$I156 nmos$1
X$2 \$1 \$5 M1_conM1M2$1
X$3 \$1 \$3 M1_conM1M2$1
X$4 \$3 \$2 \$1 \$I160 nmos$1
X$5 \$1 \$2 M1_conM1M2$1
X$6 \$2 \$9 \$1 \$I165 nmos$1
X$7 \$1 \$9 M1_conM1M2$1
X$8 \$9 \$12 \$1 \$I170 nmos$1
X$9 \$1 \$12 M1_conM1M2$1
X$10 \$12 \$6 \$1 \$I175 nmos$1
X$11 \$1 \$6 M1_conM1M2$1
X$12 \$6 \$7 \$1 \$I180 nmos$1
X$13 \$1 \$7 M1_conM1M2$1
X$14 \$5 \$3 \$1 \$I156 nmos$1
X$15 \$1 \$5 M1_conM1M2$1
X$16 \$1 \$3 M1_conM1M2$1
X$17 \$3 \$2 \$1 \$I160 nmos$1
X$18 \$1 \$2 M1_conM1M2$1
X$19 \$2 \$9 \$1 \$I165 nmos$1
X$20 \$1 \$9 M1_conM1M2$1
X$21 \$9 \$12 \$1 \$I170 nmos$1
X$22 \$1 \$12 M1_conM1M2$1
X$23 \$12 \$6 \$1 \$I175 nmos$1
X$24 \$1 \$6 M1_conM1M2$1
X$25 \$6 \$7 \$1 \$I180 nmos$1
X$26 \$1 \$7 M1_conM1M2$1
X$27 \$5 \$3 \$1 \$I156 nmos$1
X$28 \$1 \$5 M1_conM1M2$1
X$29 \$1 \$3 M1_conM1M2$1
X$30 \$3 \$2 \$1 \$I160 nmos$1
X$31 \$1 \$2 M1_conM1M2$1
X$32 \$2 \$9 \$1 \$I165 nmos$1
X$33 \$1 \$9 M1_conM1M2$1
X$34 \$9 \$12 \$1 \$I170 nmos$1
X$35 \$1 \$12 M1_conM1M2$1
X$36 \$12 \$6 \$1 \$I175 nmos$1
X$37 \$1 \$6 M1_conM1M2$1
X$38 \$6 \$7 \$1 \$I180 nmos$1
X$39 \$1 \$7 M1_conM1M2$1
X$40 \$5 \$3 \$1 \$I156 nmos$1
X$41 \$1 \$5 M1_conM1M2$1
X$42 \$1 \$3 M1_conM1M2$1
X$43 \$3 \$2 \$1 \$I160 nmos$1
X$44 \$1 \$2 M1_conM1M2$1
X$45 \$2 \$9 \$1 \$I165 nmos$1
X$46 \$1 \$9 M1_conM1M2$1
X$47 \$9 \$12 \$1 \$I170 nmos$1
X$48 \$1 \$12 M1_conM1M2$1
X$49 \$12 \$6 \$1 \$I175 nmos$1
X$50 \$1 \$6 M1_conM1M2$1
X$51 \$6 \$7 \$1 \$I180 nmos$1
X$52 \$1 \$7 M1_conM1M2$1
X$53 \$5 \$3 \$1 \$I156 nmos$1
X$54 \$3 \$2 \$1 \$I160 nmos$1
X$55 \$2 \$9 \$1 \$I165 nmos$1
X$56 \$9 \$12 \$1 \$I170 nmos$1
X$57 \$12 \$6 \$1 \$I175 nmos$1
X$58 \$6 \$7 \$1 \$I180 nmos$1
M$1 \$5 \$I156 \$3 \$1 sg13_lv_nmos L=0.15u W=1.1u AS=0.374p AD=0.209p PS=2.88u
+ PD=1.48u
M$2 \$3 \$I160 \$2 \$1 sg13_lv_nmos L=0.15u W=1.1u AS=0.209p AD=0.209p PS=1.48u
+ PD=1.48u
M$3 \$2 \$I165 \$9 \$1 sg13_lv_nmos L=0.15u W=1.1u AS=0.209p AD=0.209p PS=1.48u
+ PD=1.48u
M$4 \$9 \$I170 \$12 \$1 sg13_lv_nmos L=0.15u W=1.1u AS=0.209p AD=0.209p
+ PS=1.48u PD=1.48u
M$5 \$12 \$I175 \$6 \$1 sg13_lv_nmos L=0.15u W=1.1u AS=0.209p AD=0.209p
+ PS=1.48u PD=1.48u
M$6 \$6 \$I180 \$7 \$1 sg13_lv_nmos L=0.15u W=1.1u AS=0.209p AD=0.374p PS=1.48u
+ PD=2.88u
M$7 \$5 \$I156 \$3 \$1 sg13_lv_nmos L=0.15u W=1.1u AS=0.374p AD=0.209p PS=2.88u
+ PD=1.48u
M$8 \$3 \$I160 \$2 \$1 sg13_lv_nmos L=0.15u W=1.1u AS=0.209p AD=0.209p PS=1.48u
+ PD=1.48u
M$9 \$2 \$I165 \$9 \$1 sg13_lv_nmos L=0.15u W=1.1u AS=0.209p AD=0.209p PS=1.48u
+ PD=1.48u
M$10 \$9 \$I170 \$12 \$1 sg13_lv_nmos L=0.15u W=1.1u AS=0.209p AD=0.209p
+ PS=1.48u PD=1.48u
M$11 \$12 \$I175 \$6 \$1 sg13_lv_nmos L=0.15u W=1.1u AS=0.209p AD=0.209p
+ PS=1.48u PD=1.48u
M$12 \$6 \$I180 \$7 \$1 sg13_lv_nmos L=0.15u W=1.1u AS=0.209p AD=0.374p
+ PS=1.48u PD=2.88u
M$13 \$5 \$I156 \$3 \$1 sg13_lv_nmos L=0.15u W=1.1u AS=0.374p AD=0.209p
+ PS=2.88u PD=1.48u
M$14 \$3 \$I160 \$2 \$1 sg13_lv_nmos L=0.15u W=1.1u AS=0.209p AD=0.209p
+ PS=1.48u PD=1.48u
M$15 \$2 \$I165 \$9 \$1 sg13_lv_nmos L=0.15u W=1.1u AS=0.209p AD=0.209p
+ PS=1.48u PD=1.48u
M$16 \$9 \$I170 \$12 \$1 sg13_lv_nmos L=0.15u W=1.1u AS=0.209p AD=0.209p
+ PS=1.48u PD=1.48u
M$17 \$12 \$I175 \$6 \$1 sg13_lv_nmos L=0.15u W=1.1u AS=0.209p AD=0.209p
+ PS=1.48u PD=1.48u
M$18 \$6 \$I180 \$7 \$1 sg13_lv_nmos L=0.15u W=1.1u AS=0.209p AD=0.374p
+ PS=1.48u PD=2.88u
M$19 \$5 \$I156 \$3 \$1 sg13_lv_nmos L=0.15u W=1.1u AS=0.374p AD=0.209p
+ PS=2.88u PD=1.48u
M$20 \$3 \$I160 \$2 \$1 sg13_lv_nmos L=0.15u W=1.1u AS=0.209p AD=0.209p
+ PS=1.48u PD=1.48u
M$21 \$2 \$I165 \$9 \$1 sg13_lv_nmos L=0.15u W=1.1u AS=0.209p AD=0.209p
+ PS=1.48u PD=1.48u
M$22 \$9 \$I170 \$12 \$1 sg13_lv_nmos L=0.15u W=1.1u AS=0.209p AD=0.209p
+ PS=1.48u PD=1.48u
M$23 \$12 \$I175 \$6 \$1 sg13_lv_nmos L=0.15u W=1.1u AS=0.209p AD=0.209p
+ PS=1.48u PD=1.48u
M$24 \$6 \$I180 \$7 \$1 sg13_lv_nmos L=0.15u W=1.1u AS=0.209p AD=0.374p
+ PS=1.48u PD=2.88u
M$25 \$5 \$I156 \$3 \$1 sg13_lv_nmos L=0.15u W=1.1u AS=0.374p AD=0.209p
+ PS=2.88u PD=1.48u
M$26 \$3 \$I160 \$2 \$1 sg13_lv_nmos L=0.15u W=1.1u AS=0.209p AD=0.209p
+ PS=1.48u PD=1.48u
M$27 \$2 \$I165 \$9 \$1 sg13_lv_nmos L=0.15u W=1.1u AS=0.209p AD=0.209p
+ PS=1.48u PD=1.48u
M$28 \$9 \$I170 \$12 \$1 sg13_lv_nmos L=0.15u W=1.1u AS=0.209p AD=0.209p
+ PS=1.48u PD=1.48u
M$29 \$12 \$I175 \$6 \$1 sg13_lv_nmos L=0.15u W=1.1u AS=0.209p AD=0.209p
+ PS=1.48u PD=1.48u
M$30 \$6 \$I180 \$7 \$1 sg13_lv_nmos L=0.15u W=1.1u AS=0.209p AD=0.374p
+ PS=1.48u PD=2.88u
.ENDS M1M2$1

.SUBCKT nmos$4 \$1 \$2 \$3
M$1 \$1 \$5 \$2 \$3 sg13_lv_nmos L=0.8u W=0.5u AS=0.17p AD=0.17p PS=1.68u
+ PD=1.68u
.ENDS nmos$4

.SUBCKT Cont_M15 \$1 \$2
.ENDS Cont_M15

.SUBCKT pmos$4 \$1 \$2 \$3 \$5 \$6
.ENDS pmos$4

.SUBCKT via_stack$19 \$1 \$2
.ENDS via_stack$19

.SUBCKT pmos$5 \$1 \$2 \$3 \$5 \$6
.ENDS pmos$5

.SUBCKT M1_Cont1_PMOS \$1 \$2
.ENDS M1_Cont1_PMOS

.SUBCKT gateM9M10 \$1 \$2
X$1 \$2 \$1 via_stack$11
.ENDS gateM9M10

.SUBCKT sourceM9M10 \$1 \$2
X$1 \$1 \$2 sourceRow
X$2 \$1 \$2 sourceRow
X$3 \$1 \$2 sourceRow
X$4 \$1 \$2 sourceRow
X$5 \$1 \$2 sourceRow
X$6 \$1 \$2 sourceRow
X$7 \$1 \$2 sourceRow
X$8 \$1 \$2 sourceRow
X$9 \$1 \$2 sourceRow
X$10 \$1 \$2 sourceRow
X$11 \$1 \$2 sourceRow
X$12 \$1 \$2 sourceRow
.ENDS sourceM9M10

.SUBCKT drainM9M10 \$1 \$2
X$1 \$1 \$2 drainRowM9M10
X$2 \$1 \$2 topRowM9M10
X$3 \$1 \$2 drainRowM9M10
X$4 \$1 \$2 drainRowM9M10
X$5 \$1 \$2 drainRowM9M10
X$6 \$1 \$2 drainRowM9M10
X$7 \$1 \$2 drainRowM9M10
X$8 \$1 \$2 drainRowM9M10
X$9 \$1 \$2 drainRowM9M10
X$10 \$1 \$2 drainRowM9M10
X$11 \$1 \$2 drainRowM9M10
X$12 \$1 \$2 drainRowM9M10
X$13 \$1 \$2 drainRowM9M10
.ENDS drainM9M10

.SUBCKT M9M10 \$1 \$2 \$3 \$7 \$8 \$9 \$13 \$14 \$15 \$19 \$20 \$267 \$I1981
+ \$I1773 \$I1772 \$I1771 \$I1753 \$I1752 \$I1751 \$I1705 \$I1703 \$I828 \$I3
X$1 \$1 \$9 \$I3 \$267 \$I1751 pmos$1
X$2 \$2 \$1 \$I3 \$267 \$I828 pmos$1
X$3 \$267 \$1 M1_conM9M10
X$4 \$1 \$9 \$I3 \$267 \$I1751 pmos$1
X$5 \$2 \$1 \$I3 \$267 \$I828 pmos$1
X$6 \$267 \$1 M1_conM9M10
X$7 \$1 \$9 \$I3 \$267 \$I1751 pmos$1
X$8 \$2 \$1 \$I3 \$267 \$I828 pmos$1
X$9 \$267 \$1 M1_conM9M10
X$10 \$1 \$9 \$I3 \$267 \$I1751 pmos$1
X$11 \$2 \$1 \$I3 \$267 \$I828 pmos$1
X$12 \$267 \$1 M1_conM9M10
X$13 \$1 \$9 \$I3 \$267 \$I1751 pmos$1
X$14 \$2 \$1 \$I3 \$267 \$I828 pmos$1
X$15 \$267 \$1 M1_conM9M10
X$16 \$1 \$9 \$I3 \$267 \$I1751 pmos$1
X$17 \$2 \$1 \$I3 \$267 \$I828 pmos$1
X$18 \$267 \$1 M1_conM9M10
X$19 \$1 \$9 \$I3 \$267 \$I1751 pmos$1
X$20 \$2 \$1 \$I3 \$267 \$I828 pmos$1
X$21 \$267 \$1 M1_conM9M10
X$22 \$1 \$9 \$I3 \$267 \$I1751 pmos$1
X$23 \$2 \$1 \$I3 \$267 \$I828 pmos$1
X$24 \$267 \$1 M1_conM9M10
X$25 \$1 \$9 \$I3 \$267 \$I1751 pmos$1
X$26 \$2 \$1 \$I3 \$267 \$I828 pmos$1
X$27 \$267 \$1 M1_conM9M10
X$28 \$1 \$9 \$I3 \$267 \$I1751 pmos$1
X$29 \$2 \$1 \$I3 \$267 \$I828 pmos$1
X$30 \$267 \$1 M1_conM9M10
X$31 \$1 \$9 \$I3 \$267 \$I1751 pmos$1
X$32 \$2 \$1 \$I3 \$267 \$I828 pmos$1
X$33 \$267 \$1 M1_conM9M10
X$34 \$1 \$9 \$I3 \$267 \$I1751 pmos$1
X$35 \$2 \$1 \$I3 \$267 \$I828 pmos$1
X$36 \$267 \$1 M1_conM9M10
X$37 \$1 \$9 \$I3 \$267 \$I1751 pmos$1
X$38 \$2 \$1 \$I3 \$267 \$I828 pmos$1
X$39 \$267 \$1 M1_conM9M10
X$40 \$1 \$9 \$I3 \$267 \$I1751 pmos$1
X$41 \$2 \$1 \$I3 \$267 \$I828 pmos$1
X$42 \$267 \$1 M1_conM9M10
X$43 \$1 \$9 \$I3 \$267 \$I1751 pmos$1
X$44 \$2 \$1 \$I3 \$267 \$I828 pmos$1
X$45 \$267 \$1 M1_conM9M10
X$46 \$1 \$9 \$I3 \$267 \$I1751 pmos$1
X$47 \$2 \$1 \$I3 \$267 \$I828 pmos$1
X$48 \$267 \$1 M1_conM9M10
X$49 \$1 \$9 \$I3 \$267 \$I1751 pmos$1
X$50 \$2 \$1 \$I3 \$267 \$I828 pmos$1
X$51 \$267 \$1 M1_conM9M10
X$52 \$1 \$9 \$I3 \$267 \$I1751 pmos$1
X$53 \$2 \$1 \$I3 \$267 \$I828 pmos$1
X$54 \$267 \$1 M1_conM9M10
X$55 \$1 \$9 \$I3 \$267 \$I1751 pmos$1
X$56 \$2 \$1 \$I3 \$267 \$I828 pmos$1
X$57 \$267 \$1 M1_conM9M10
X$58 \$1 \$9 \$I3 \$267 \$I1751 pmos$1
X$59 \$2 \$1 \$I3 \$267 \$I828 pmos$1
X$60 \$267 \$1 M1_conM9M10
X$61 \$1 \$9 \$I3 \$267 \$I1751 pmos$1
X$62 \$2 \$1 \$I3 \$267 \$I828 pmos$1
X$63 \$267 \$1 M1_conM9M10
X$64 \$1 \$9 \$I3 \$267 \$I1751 pmos$1
X$65 \$2 \$1 \$I3 \$267 \$I828 pmos$1
X$66 \$267 \$1 M1_conM9M10
X$67 \$1 \$9 \$I3 \$267 \$I1751 pmos$1
X$68 \$2 \$1 \$I3 \$267 \$I828 pmos$1
X$69 \$267 \$1 M1_conM9M10
X$70 \$1 \$9 \$I3 \$267 \$I1751 pmos$1
X$71 \$2 \$1 \$I3 \$267 \$I828 pmos$1
X$72 \$267 \$1 M1_conM9M10
X$73 \$1 \$9 \$I3 \$267 \$I1751 pmos$1
X$74 \$2 \$1 \$I3 \$267 \$I828 pmos$1
X$75 \$267 \$2 M1_conM9M10
X$76 \$267 \$2 M1_conM9M10
X$77 \$267 \$2 M1_conM9M10
X$78 \$267 \$2 M1_conM9M10
X$79 \$267 \$2 M1_conM9M10
X$80 \$267 \$2 M1_conM9M10
X$81 \$267 \$2 M1_conM9M10
X$82 \$267 \$2 M1_conM9M10
X$83 \$267 \$2 M1_conM9M10
X$84 \$267 \$2 M1_conM9M10
X$85 \$267 \$2 M1_conM9M10
X$86 \$267 \$2 M1_conM9M10
X$87 \$267 \$2 M1_conM9M10
X$88 \$267 \$2 M1_conM9M10
X$89 \$267 \$2 M1_conM9M10
X$90 \$267 \$2 M1_conM9M10
X$91 \$267 \$2 M1_conM9M10
X$92 \$267 \$2 M1_conM9M10
X$93 \$267 \$2 M1_conM9M10
X$94 \$267 \$2 M1_conM9M10
X$95 \$267 \$2 M1_conM9M10
X$96 \$267 \$2 M1_conM9M10
X$97 \$267 \$2 M1_conM9M10
X$98 \$267 \$2 M1_conM9M10
X$99 \$8 \$3 \$I3 \$267 \$I1981 pmos$1
X$100 \$267 \$3 M1_conM9M10
X$101 \$8 \$3 \$I3 \$267 \$I1981 pmos$1
X$102 \$267 \$3 M1_conM9M10
X$103 \$8 \$3 \$I3 \$267 \$I1981 pmos$1
X$104 \$267 \$3 M1_conM9M10
X$105 \$8 \$3 \$I3 \$267 \$I1981 pmos$1
X$106 \$267 \$3 M1_conM9M10
X$107 \$8 \$3 \$I3 \$267 \$I1981 pmos$1
X$108 \$267 \$3 M1_conM9M10
X$109 \$8 \$3 \$I3 \$267 \$I1981 pmos$1
X$110 \$267 \$3 M1_conM9M10
X$111 \$8 \$3 \$I3 \$267 \$I1981 pmos$1
X$112 \$267 \$3 M1_conM9M10
X$113 \$8 \$3 \$I3 \$267 \$I1981 pmos$1
X$114 \$267 \$3 M1_conM9M10
X$115 \$8 \$3 \$I3 \$267 \$I1981 pmos$1
X$116 \$267 \$3 M1_conM9M10
X$117 \$8 \$3 \$I3 \$267 \$I1981 pmos$1
X$118 \$267 \$3 M1_conM9M10
X$119 \$8 \$3 \$I3 \$267 \$I1981 pmos$1
X$120 \$267 \$3 M1_conM9M10
X$121 \$8 \$3 \$I3 \$267 \$I1981 pmos$1
X$122 \$267 \$3 M1_conM9M10
X$123 \$8 \$3 \$I3 \$267 \$I1981 pmos$1
X$124 \$267 \$3 M1_conM9M10
X$125 \$8 \$3 \$I3 \$267 \$I1981 pmos$1
X$126 \$267 \$3 M1_conM9M10
X$127 \$8 \$3 \$I3 \$267 \$I1981 pmos$1
X$128 \$267 \$3 M1_conM9M10
X$129 \$8 \$3 \$I3 \$267 \$I1981 pmos$1
X$130 \$267 \$3 M1_conM9M10
X$131 \$8 \$3 \$I3 \$267 \$I1981 pmos$1
X$132 \$267 \$3 M1_conM9M10
X$133 \$8 \$3 \$I3 \$267 \$I1981 pmos$1
X$134 \$267 \$3 M1_conM9M10
X$135 \$8 \$3 \$I3 \$267 \$I1981 pmos$1
X$136 \$267 \$3 M1_conM9M10
X$137 \$8 \$3 \$I3 \$267 \$I1981 pmos$1
X$138 \$267 \$3 M1_conM9M10
X$139 \$8 \$3 \$I3 \$267 \$I1981 pmos$1
X$140 \$267 \$3 M1_conM9M10
X$141 \$8 \$3 \$I3 \$267 \$I1981 pmos$1
X$142 \$267 \$3 M1_conM9M10
X$143 \$8 \$3 \$I3 \$267 \$I1981 pmos$1
X$144 \$267 \$3 M1_conM9M10
X$145 \$8 \$3 \$I3 \$267 \$I1981 pmos$1
X$146 \$267 \$3 M1_conM9M10
X$147 \$8 \$3 \$I3 \$267 \$I1981 pmos$1
X$148 \$7 \$14 \$I3 \$267 \$I1753 pmos$1
X$149 \$9 \$7 \$I3 \$267 \$I1752 pmos$1
X$150 \$267 \$7 M1_conM9M10
X$151 \$7 \$14 \$I3 \$267 \$I1753 pmos$1
X$152 \$9 \$7 \$I3 \$267 \$I1752 pmos$1
X$153 \$267 \$7 M1_conM9M10
X$154 \$7 \$14 \$I3 \$267 \$I1753 pmos$1
X$155 \$9 \$7 \$I3 \$267 \$I1752 pmos$1
X$156 \$267 \$7 M1_conM9M10
X$157 \$7 \$14 \$I3 \$267 \$I1753 pmos$1
X$158 \$9 \$7 \$I3 \$267 \$I1752 pmos$1
X$159 \$267 \$7 M1_conM9M10
X$160 \$7 \$14 \$I3 \$267 \$I1753 pmos$1
X$161 \$9 \$7 \$I3 \$267 \$I1752 pmos$1
X$162 \$267 \$7 M1_conM9M10
X$163 \$7 \$14 \$I3 \$267 \$I1753 pmos$1
X$164 \$9 \$7 \$I3 \$267 \$I1752 pmos$1
X$165 \$267 \$7 M1_conM9M10
X$166 \$7 \$14 \$I3 \$267 \$I1753 pmos$1
X$167 \$9 \$7 \$I3 \$267 \$I1752 pmos$1
X$168 \$267 \$7 M1_conM9M10
X$169 \$7 \$14 \$I3 \$267 \$I1753 pmos$1
X$170 \$9 \$7 \$I3 \$267 \$I1752 pmos$1
X$171 \$267 \$7 M1_conM9M10
X$172 \$7 \$14 \$I3 \$267 \$I1753 pmos$1
X$173 \$9 \$7 \$I3 \$267 \$I1752 pmos$1
X$174 \$267 \$7 M1_conM9M10
X$175 \$7 \$14 \$I3 \$267 \$I1753 pmos$1
X$176 \$9 \$7 \$I3 \$267 \$I1752 pmos$1
X$177 \$267 \$7 M1_conM9M10
X$178 \$7 \$14 \$I3 \$267 \$I1753 pmos$1
X$179 \$9 \$7 \$I3 \$267 \$I1752 pmos$1
X$180 \$267 \$7 M1_conM9M10
X$181 \$7 \$14 \$I3 \$267 \$I1753 pmos$1
X$182 \$9 \$7 \$I3 \$267 \$I1752 pmos$1
X$183 \$267 \$7 M1_conM9M10
X$184 \$7 \$14 \$I3 \$267 \$I1753 pmos$1
X$185 \$9 \$7 \$I3 \$267 \$I1752 pmos$1
X$186 \$267 \$7 M1_conM9M10
X$187 \$7 \$14 \$I3 \$267 \$I1753 pmos$1
X$188 \$9 \$7 \$I3 \$267 \$I1752 pmos$1
X$189 \$267 \$7 M1_conM9M10
X$190 \$7 \$14 \$I3 \$267 \$I1753 pmos$1
X$191 \$9 \$7 \$I3 \$267 \$I1752 pmos$1
X$192 \$267 \$7 M1_conM9M10
X$193 \$7 \$14 \$I3 \$267 \$I1753 pmos$1
X$194 \$9 \$7 \$I3 \$267 \$I1752 pmos$1
X$195 \$267 \$7 M1_conM9M10
X$196 \$7 \$14 \$I3 \$267 \$I1753 pmos$1
X$197 \$9 \$7 \$I3 \$267 \$I1752 pmos$1
X$198 \$267 \$7 M1_conM9M10
X$199 \$7 \$14 \$I3 \$267 \$I1753 pmos$1
X$200 \$9 \$7 \$I3 \$267 \$I1752 pmos$1
X$201 \$267 \$7 M1_conM9M10
X$202 \$7 \$14 \$I3 \$267 \$I1753 pmos$1
X$203 \$9 \$7 \$I3 \$267 \$I1752 pmos$1
X$204 \$267 \$7 M1_conM9M10
X$205 \$7 \$14 \$I3 \$267 \$I1753 pmos$1
X$206 \$9 \$7 \$I3 \$267 \$I1752 pmos$1
X$207 \$267 \$7 M1_conM9M10
X$208 \$7 \$14 \$I3 \$267 \$I1753 pmos$1
X$209 \$9 \$7 \$I3 \$267 \$I1752 pmos$1
X$210 \$267 \$7 M1_conM9M10
X$211 \$7 \$14 \$I3 \$267 \$I1753 pmos$1
X$212 \$9 \$7 \$I3 \$267 \$I1752 pmos$1
X$213 \$267 \$7 M1_conM9M10
X$214 \$7 \$14 \$I3 \$267 \$I1753 pmos$1
X$215 \$9 \$7 \$I3 \$267 \$I1752 pmos$1
X$216 \$267 \$7 M1_conM9M10
X$217 \$7 \$14 \$I3 \$267 \$I1753 pmos$1
X$218 \$9 \$7 \$I3 \$267 \$I1752 pmos$1
X$219 \$267 \$7 M1_conM9M10
X$220 \$7 \$14 \$I3 \$267 \$I1753 pmos$1
X$221 \$9 \$7 \$I3 \$267 \$I1752 pmos$1
X$222 \$15 \$8 \$I3 \$267 \$I1773 pmos$1
X$223 \$267 \$8 M1_conM9M10
X$224 \$15 \$8 \$I3 \$267 \$I1773 pmos$1
X$225 \$267 \$8 M1_conM9M10
X$226 \$15 \$8 \$I3 \$267 \$I1773 pmos$1
X$227 \$267 \$8 M1_conM9M10
X$228 \$15 \$8 \$I3 \$267 \$I1773 pmos$1
X$229 \$267 \$8 M1_conM9M10
X$230 \$15 \$8 \$I3 \$267 \$I1773 pmos$1
X$231 \$267 \$8 M1_conM9M10
X$232 \$15 \$8 \$I3 \$267 \$I1773 pmos$1
X$233 \$267 \$8 M1_conM9M10
X$234 \$15 \$8 \$I3 \$267 \$I1773 pmos$1
X$235 \$267 \$8 M1_conM9M10
X$236 \$15 \$8 \$I3 \$267 \$I1773 pmos$1
X$237 \$267 \$8 M1_conM9M10
X$238 \$15 \$8 \$I3 \$267 \$I1773 pmos$1
X$239 \$267 \$8 M1_conM9M10
X$240 \$15 \$8 \$I3 \$267 \$I1773 pmos$1
X$241 \$267 \$8 M1_conM9M10
X$242 \$15 \$8 \$I3 \$267 \$I1773 pmos$1
X$243 \$267 \$8 M1_conM9M10
X$244 \$15 \$8 \$I3 \$267 \$I1773 pmos$1
X$245 \$267 \$8 M1_conM9M10
X$246 \$15 \$8 \$I3 \$267 \$I1773 pmos$1
X$247 \$267 \$8 M1_conM9M10
X$248 \$15 \$8 \$I3 \$267 \$I1773 pmos$1
X$249 \$267 \$8 M1_conM9M10
X$250 \$15 \$8 \$I3 \$267 \$I1773 pmos$1
X$251 \$267 \$8 M1_conM9M10
X$252 \$15 \$8 \$I3 \$267 \$I1773 pmos$1
X$253 \$267 \$8 M1_conM9M10
X$254 \$15 \$8 \$I3 \$267 \$I1773 pmos$1
X$255 \$267 \$8 M1_conM9M10
X$256 \$15 \$8 \$I3 \$267 \$I1773 pmos$1
X$257 \$267 \$8 M1_conM9M10
X$258 \$15 \$8 \$I3 \$267 \$I1773 pmos$1
X$259 \$267 \$8 M1_conM9M10
X$260 \$15 \$8 \$I3 \$267 \$I1773 pmos$1
X$261 \$267 \$8 M1_conM9M10
X$262 \$15 \$8 \$I3 \$267 \$I1773 pmos$1
X$263 \$267 \$8 M1_conM9M10
X$264 \$15 \$8 \$I3 \$267 \$I1773 pmos$1
X$265 \$267 \$8 M1_conM9M10
X$266 \$15 \$8 \$I3 \$267 \$I1773 pmos$1
X$267 \$267 \$8 M1_conM9M10
X$268 \$15 \$8 \$I3 \$267 \$I1773 pmos$1
X$269 \$267 \$8 M1_conM9M10
X$270 \$15 \$8 \$I3 \$267 \$I1773 pmos$1
X$271 \$267 \$9 M1_conM9M10
X$272 \$267 \$9 M1_conM9M10
X$273 \$267 \$9 M1_conM9M10
X$274 \$267 \$9 M1_conM9M10
X$275 \$267 \$9 M1_conM9M10
X$276 \$267 \$9 M1_conM9M10
X$277 \$267 \$9 M1_conM9M10
X$278 \$267 \$9 M1_conM9M10
X$279 \$267 \$9 M1_conM9M10
X$280 \$267 \$9 M1_conM9M10
X$281 \$267 \$9 M1_conM9M10
X$282 \$267 \$9 M1_conM9M10
X$283 \$267 \$9 M1_conM9M10
X$284 \$267 \$9 M1_conM9M10
X$285 \$267 \$9 M1_conM9M10
X$286 \$267 \$9 M1_conM9M10
X$287 \$267 \$9 M1_conM9M10
X$288 \$267 \$9 M1_conM9M10
X$289 \$267 \$9 M1_conM9M10
X$290 \$267 \$9 M1_conM9M10
X$291 \$267 \$9 M1_conM9M10
X$292 \$267 \$9 M1_conM9M10
X$293 \$267 \$9 M1_conM9M10
X$294 \$267 \$9 M1_conM9M10
X$295 \$13 \$20 \$I3 \$267 \$I1705 pmos$1
X$296 \$14 \$13 \$I3 \$267 \$I1703 pmos$1
X$297 \$267 \$13 M1_conM9M10
X$298 \$13 \$20 \$I3 \$267 \$I1705 pmos$1
X$299 \$14 \$13 \$I3 \$267 \$I1703 pmos$1
X$300 \$267 \$13 M1_conM9M10
X$301 \$13 \$20 \$I3 \$267 \$I1705 pmos$1
X$302 \$14 \$13 \$I3 \$267 \$I1703 pmos$1
X$303 \$267 \$13 M1_conM9M10
X$304 \$13 \$20 \$I3 \$267 \$I1705 pmos$1
X$305 \$14 \$13 \$I3 \$267 \$I1703 pmos$1
X$306 \$267 \$13 M1_conM9M10
X$307 \$13 \$20 \$I3 \$267 \$I1705 pmos$1
X$308 \$14 \$13 \$I3 \$267 \$I1703 pmos$1
X$309 \$267 \$13 M1_conM9M10
X$310 \$13 \$20 \$I3 \$267 \$I1705 pmos$1
X$311 \$14 \$13 \$I3 \$267 \$I1703 pmos$1
X$312 \$267 \$13 M1_conM9M10
X$313 \$13 \$20 \$I3 \$267 \$I1705 pmos$1
X$314 \$14 \$13 \$I3 \$267 \$I1703 pmos$1
X$315 \$267 \$13 M1_conM9M10
X$316 \$13 \$20 \$I3 \$267 \$I1705 pmos$1
X$317 \$14 \$13 \$I3 \$267 \$I1703 pmos$1
X$318 \$267 \$13 M1_conM9M10
X$319 \$13 \$20 \$I3 \$267 \$I1705 pmos$1
X$320 \$14 \$13 \$I3 \$267 \$I1703 pmos$1
X$321 \$267 \$13 M1_conM9M10
X$322 \$13 \$20 \$I3 \$267 \$I1705 pmos$1
X$323 \$14 \$13 \$I3 \$267 \$I1703 pmos$1
X$324 \$267 \$13 M1_conM9M10
X$325 \$13 \$20 \$I3 \$267 \$I1705 pmos$1
X$326 \$14 \$13 \$I3 \$267 \$I1703 pmos$1
X$327 \$267 \$13 M1_conM9M10
X$328 \$13 \$20 \$I3 \$267 \$I1705 pmos$1
X$329 \$14 \$13 \$I3 \$267 \$I1703 pmos$1
X$330 \$267 \$13 M1_conM9M10
X$331 \$13 \$20 \$I3 \$267 \$I1705 pmos$1
X$332 \$14 \$13 \$I3 \$267 \$I1703 pmos$1
X$333 \$267 \$13 M1_conM9M10
X$334 \$13 \$20 \$I3 \$267 \$I1705 pmos$1
X$335 \$14 \$13 \$I3 \$267 \$I1703 pmos$1
X$336 \$267 \$13 M1_conM9M10
X$337 \$13 \$20 \$I3 \$267 \$I1705 pmos$1
X$338 \$14 \$13 \$I3 \$267 \$I1703 pmos$1
X$339 \$267 \$13 M1_conM9M10
X$340 \$13 \$20 \$I3 \$267 \$I1705 pmos$1
X$341 \$14 \$13 \$I3 \$267 \$I1703 pmos$1
X$342 \$267 \$13 M1_conM9M10
X$343 \$13 \$20 \$I3 \$267 \$I1705 pmos$1
X$344 \$14 \$13 \$I3 \$267 \$I1703 pmos$1
X$345 \$267 \$13 M1_conM9M10
X$346 \$13 \$20 \$I3 \$267 \$I1705 pmos$1
X$347 \$14 \$13 \$I3 \$267 \$I1703 pmos$1
X$348 \$267 \$13 M1_conM9M10
X$349 \$13 \$20 \$I3 \$267 \$I1705 pmos$1
X$350 \$14 \$13 \$I3 \$267 \$I1703 pmos$1
X$351 \$267 \$13 M1_conM9M10
X$352 \$13 \$20 \$I3 \$267 \$I1705 pmos$1
X$353 \$14 \$13 \$I3 \$267 \$I1703 pmos$1
X$354 \$267 \$13 M1_conM9M10
X$355 \$13 \$20 \$I3 \$267 \$I1705 pmos$1
X$356 \$14 \$13 \$I3 \$267 \$I1703 pmos$1
X$357 \$267 \$13 M1_conM9M10
X$358 \$13 \$20 \$I3 \$267 \$I1705 pmos$1
X$359 \$14 \$13 \$I3 \$267 \$I1703 pmos$1
X$360 \$267 \$13 M1_conM9M10
X$361 \$13 \$20 \$I3 \$267 \$I1705 pmos$1
X$362 \$14 \$13 \$I3 \$267 \$I1703 pmos$1
X$363 \$267 \$13 M1_conM9M10
X$364 \$13 \$20 \$I3 \$267 \$I1705 pmos$1
X$365 \$14 \$13 \$I3 \$267 \$I1703 pmos$1
X$366 \$267 \$13 M1_conM9M10
X$367 \$13 \$20 \$I3 \$267 \$I1705 pmos$1
X$368 \$14 \$13 \$I3 \$267 \$I1703 pmos$1
X$369 \$267 \$14 M1_conM9M10
X$370 \$267 \$14 M1_conM9M10
X$371 \$267 \$14 M1_conM9M10
X$372 \$267 \$14 M1_conM9M10
X$373 \$267 \$14 M1_conM9M10
X$374 \$267 \$14 M1_conM9M10
X$375 \$267 \$14 M1_conM9M10
X$376 \$267 \$14 M1_conM9M10
X$377 \$267 \$14 M1_conM9M10
X$378 \$267 \$14 M1_conM9M10
X$379 \$267 \$14 M1_conM9M10
X$380 \$267 \$14 M1_conM9M10
X$381 \$267 \$14 M1_conM9M10
X$382 \$267 \$14 M1_conM9M10
X$383 \$267 \$14 M1_conM9M10
X$384 \$267 \$14 M1_conM9M10
X$385 \$267 \$14 M1_conM9M10
X$386 \$267 \$14 M1_conM9M10
X$387 \$267 \$14 M1_conM9M10
X$388 \$267 \$14 M1_conM9M10
X$389 \$267 \$14 M1_conM9M10
X$390 \$267 \$14 M1_conM9M10
X$391 \$267 \$14 M1_conM9M10
X$392 \$267 \$14 M1_conM9M10
X$393 \$19 \$15 \$I3 \$267 \$I1772 pmos$1
X$394 \$267 \$15 M1_conM9M10
X$395 \$19 \$15 \$I3 \$267 \$I1772 pmos$1
X$396 \$267 \$15 M1_conM9M10
X$397 \$19 \$15 \$I3 \$267 \$I1772 pmos$1
X$398 \$267 \$15 M1_conM9M10
X$399 \$19 \$15 \$I3 \$267 \$I1772 pmos$1
X$400 \$267 \$15 M1_conM9M10
X$401 \$19 \$15 \$I3 \$267 \$I1772 pmos$1
X$402 \$267 \$15 M1_conM9M10
X$403 \$19 \$15 \$I3 \$267 \$I1772 pmos$1
X$404 \$267 \$15 M1_conM9M10
X$405 \$19 \$15 \$I3 \$267 \$I1772 pmos$1
X$406 \$267 \$15 M1_conM9M10
X$407 \$19 \$15 \$I3 \$267 \$I1772 pmos$1
X$408 \$267 \$15 M1_conM9M10
X$409 \$19 \$15 \$I3 \$267 \$I1772 pmos$1
X$410 \$267 \$15 M1_conM9M10
X$411 \$19 \$15 \$I3 \$267 \$I1772 pmos$1
X$412 \$267 \$15 M1_conM9M10
X$413 \$19 \$15 \$I3 \$267 \$I1772 pmos$1
X$414 \$267 \$15 M1_conM9M10
X$415 \$19 \$15 \$I3 \$267 \$I1772 pmos$1
X$416 \$267 \$15 M1_conM9M10
X$417 \$19 \$15 \$I3 \$267 \$I1772 pmos$1
X$418 \$267 \$15 M1_conM9M10
X$419 \$19 \$15 \$I3 \$267 \$I1772 pmos$1
X$420 \$267 \$15 M1_conM9M10
X$421 \$19 \$15 \$I3 \$267 \$I1772 pmos$1
X$422 \$267 \$15 M1_conM9M10
X$423 \$19 \$15 \$I3 \$267 \$I1772 pmos$1
X$424 \$267 \$15 M1_conM9M10
X$425 \$19 \$15 \$I3 \$267 \$I1772 pmos$1
X$426 \$267 \$15 M1_conM9M10
X$427 \$19 \$15 \$I3 \$267 \$I1772 pmos$1
X$428 \$267 \$15 M1_conM9M10
X$429 \$19 \$15 \$I3 \$267 \$I1772 pmos$1
X$430 \$267 \$15 M1_conM9M10
X$431 \$19 \$15 \$I3 \$267 \$I1772 pmos$1
X$432 \$267 \$15 M1_conM9M10
X$433 \$19 \$15 \$I3 \$267 \$I1772 pmos$1
X$434 \$267 \$15 M1_conM9M10
X$435 \$19 \$15 \$I3 \$267 \$I1772 pmos$1
X$436 \$267 \$15 M1_conM9M10
X$437 \$19 \$15 \$I3 \$267 \$I1772 pmos$1
X$438 \$267 \$15 M1_conM9M10
X$439 \$19 \$15 \$I3 \$267 \$I1772 pmos$1
X$440 \$267 \$15 M1_conM9M10
X$441 \$19 \$15 \$I3 \$267 \$I1772 pmos$1
X$442 \$20 \$19 \$I3 \$267 \$I1771 pmos$1
X$443 \$267 \$19 M1_conM9M10
X$444 \$20 \$19 \$I3 \$267 \$I1771 pmos$1
X$445 \$267 \$19 M1_conM9M10
X$446 \$20 \$19 \$I3 \$267 \$I1771 pmos$1
X$447 \$267 \$19 M1_conM9M10
X$448 \$20 \$19 \$I3 \$267 \$I1771 pmos$1
X$449 \$267 \$19 M1_conM9M10
X$450 \$20 \$19 \$I3 \$267 \$I1771 pmos$1
X$451 \$267 \$19 M1_conM9M10
X$452 \$20 \$19 \$I3 \$267 \$I1771 pmos$1
X$453 \$267 \$19 M1_conM9M10
X$454 \$20 \$19 \$I3 \$267 \$I1771 pmos$1
X$455 \$267 \$19 M1_conM9M10
X$456 \$20 \$19 \$I3 \$267 \$I1771 pmos$1
X$457 \$267 \$19 M1_conM9M10
X$458 \$20 \$19 \$I3 \$267 \$I1771 pmos$1
X$459 \$267 \$19 M1_conM9M10
X$460 \$20 \$19 \$I3 \$267 \$I1771 pmos$1
X$461 \$267 \$19 M1_conM9M10
X$462 \$20 \$19 \$I3 \$267 \$I1771 pmos$1
X$463 \$267 \$19 M1_conM9M10
X$464 \$20 \$19 \$I3 \$267 \$I1771 pmos$1
X$465 \$267 \$19 M1_conM9M10
X$466 \$20 \$19 \$I3 \$267 \$I1771 pmos$1
X$467 \$267 \$19 M1_conM9M10
X$468 \$20 \$19 \$I3 \$267 \$I1771 pmos$1
X$469 \$267 \$19 M1_conM9M10
X$470 \$20 \$19 \$I3 \$267 \$I1771 pmos$1
X$471 \$267 \$19 M1_conM9M10
X$472 \$20 \$19 \$I3 \$267 \$I1771 pmos$1
X$473 \$267 \$19 M1_conM9M10
X$474 \$20 \$19 \$I3 \$267 \$I1771 pmos$1
X$475 \$267 \$19 M1_conM9M10
X$476 \$20 \$19 \$I3 \$267 \$I1771 pmos$1
X$477 \$267 \$19 M1_conM9M10
X$478 \$20 \$19 \$I3 \$267 \$I1771 pmos$1
X$479 \$267 \$19 M1_conM9M10
X$480 \$20 \$19 \$I3 \$267 \$I1771 pmos$1
X$481 \$267 \$19 M1_conM9M10
X$482 \$20 \$19 \$I3 \$267 \$I1771 pmos$1
X$483 \$267 \$19 M1_conM9M10
X$484 \$20 \$19 \$I3 \$267 \$I1771 pmos$1
X$485 \$267 \$19 M1_conM9M10
X$486 \$20 \$19 \$I3 \$267 \$I1771 pmos$1
X$487 \$267 \$19 M1_conM9M10
X$488 \$20 \$19 \$I3 \$267 \$I1771 pmos$1
X$489 \$267 \$19 M1_conM9M10
X$490 \$20 \$19 \$I3 \$267 \$I1771 pmos$1
X$491 \$267 \$20 M1_conM9M10
X$492 \$267 \$20 M1_conM9M10
X$493 \$267 \$20 M1_conM9M10
X$494 \$267 \$20 M1_conM9M10
X$495 \$267 \$20 M1_conM9M10
X$496 \$267 \$20 M1_conM9M10
X$497 \$267 \$20 M1_conM9M10
X$498 \$267 \$20 M1_conM9M10
X$499 \$267 \$20 M1_conM9M10
X$500 \$267 \$20 M1_conM9M10
X$501 \$267 \$20 M1_conM9M10
X$502 \$267 \$20 M1_conM9M10
X$503 \$267 \$20 M1_conM9M10
X$504 \$267 \$20 M1_conM9M10
X$505 \$267 \$20 M1_conM9M10
X$506 \$267 \$20 M1_conM9M10
X$507 \$267 \$20 M1_conM9M10
X$508 \$267 \$20 M1_conM9M10
X$509 \$267 \$20 M1_conM9M10
X$510 \$267 \$20 M1_conM9M10
X$511 \$267 \$20 M1_conM9M10
X$512 \$267 \$20 M1_conM9M10
X$513 \$267 \$20 M1_conM9M10
X$514 \$267 \$20 M1_conM9M10
M$1 \$2 \$I828 \$1 \$I3 sg13_lv_pmos L=0.35u W=1.37u AS=0.4658p AD=0.2603p
+ PS=3.42u PD=1.75u
M$2 \$1 \$I1751 \$9 \$I3 sg13_lv_pmos L=0.35u W=1.37u AS=0.2603p AD=0.2603p
+ PS=1.75u PD=1.75u
M$3 \$9 \$I1752 \$7 \$I3 sg13_lv_pmos L=0.35u W=1.37u AS=0.2603p AD=0.2603p
+ PS=1.75u PD=1.75u
M$4 \$7 \$I1753 \$14 \$I3 sg13_lv_pmos L=0.35u W=1.37u AS=0.2603p AD=0.2603p
+ PS=1.75u PD=1.75u
M$5 \$14 \$I1703 \$13 \$I3 sg13_lv_pmos L=0.35u W=1.37u AS=0.2603p AD=0.2603p
+ PS=1.75u PD=1.75u
M$6 \$13 \$I1705 \$20 \$I3 sg13_lv_pmos L=0.35u W=1.37u AS=0.2603p AD=0.2603p
+ PS=1.75u PD=1.75u
M$7 \$20 \$I1771 \$19 \$I3 sg13_lv_pmos L=0.35u W=1.37u AS=0.2603p AD=0.2603p
+ PS=1.75u PD=1.75u
M$8 \$19 \$I1772 \$15 \$I3 sg13_lv_pmos L=0.35u W=1.37u AS=0.2603p AD=0.2603p
+ PS=1.75u PD=1.75u
M$9 \$15 \$I1773 \$8 \$I3 sg13_lv_pmos L=0.35u W=1.37u AS=0.2603p AD=0.2603p
+ PS=1.75u PD=1.75u
M$10 \$8 \$I1981 \$3 \$I3 sg13_lv_pmos L=0.35u W=1.37u AS=0.2603p AD=0.4658p
+ PS=1.75u PD=3.42u
M$11 \$2 \$I828 \$1 \$I3 sg13_lv_pmos L=0.35u W=1.37u AS=0.4658p AD=0.2603p
+ PS=3.42u PD=1.75u
M$12 \$1 \$I1751 \$9 \$I3 sg13_lv_pmos L=0.35u W=1.37u AS=0.2603p AD=0.2603p
+ PS=1.75u PD=1.75u
M$13 \$9 \$I1752 \$7 \$I3 sg13_lv_pmos L=0.35u W=1.37u AS=0.2603p AD=0.2603p
+ PS=1.75u PD=1.75u
M$14 \$7 \$I1753 \$14 \$I3 sg13_lv_pmos L=0.35u W=1.37u AS=0.2603p AD=0.2603p
+ PS=1.75u PD=1.75u
M$15 \$14 \$I1703 \$13 \$I3 sg13_lv_pmos L=0.35u W=1.37u AS=0.2603p AD=0.2603p
+ PS=1.75u PD=1.75u
M$16 \$13 \$I1705 \$20 \$I3 sg13_lv_pmos L=0.35u W=1.37u AS=0.2603p AD=0.2603p
+ PS=1.75u PD=1.75u
M$17 \$20 \$I1771 \$19 \$I3 sg13_lv_pmos L=0.35u W=1.37u AS=0.2603p AD=0.2603p
+ PS=1.75u PD=1.75u
M$18 \$19 \$I1772 \$15 \$I3 sg13_lv_pmos L=0.35u W=1.37u AS=0.2603p AD=0.2603p
+ PS=1.75u PD=1.75u
M$19 \$15 \$I1773 \$8 \$I3 sg13_lv_pmos L=0.35u W=1.37u AS=0.2603p AD=0.2603p
+ PS=1.75u PD=1.75u
M$20 \$8 \$I1981 \$3 \$I3 sg13_lv_pmos L=0.35u W=1.37u AS=0.2603p AD=0.4658p
+ PS=1.75u PD=3.42u
M$21 \$2 \$I828 \$1 \$I3 sg13_lv_pmos L=0.35u W=1.37u AS=0.4658p AD=0.2603p
+ PS=3.42u PD=1.75u
M$22 \$1 \$I1751 \$9 \$I3 sg13_lv_pmos L=0.35u W=1.37u AS=0.2603p AD=0.2603p
+ PS=1.75u PD=1.75u
M$23 \$9 \$I1752 \$7 \$I3 sg13_lv_pmos L=0.35u W=1.37u AS=0.2603p AD=0.2603p
+ PS=1.75u PD=1.75u
M$24 \$7 \$I1753 \$14 \$I3 sg13_lv_pmos L=0.35u W=1.37u AS=0.2603p AD=0.2603p
+ PS=1.75u PD=1.75u
M$25 \$14 \$I1703 \$13 \$I3 sg13_lv_pmos L=0.35u W=1.37u AS=0.2603p AD=0.2603p
+ PS=1.75u PD=1.75u
M$26 \$13 \$I1705 \$20 \$I3 sg13_lv_pmos L=0.35u W=1.37u AS=0.2603p AD=0.2603p
+ PS=1.75u PD=1.75u
M$27 \$20 \$I1771 \$19 \$I3 sg13_lv_pmos L=0.35u W=1.37u AS=0.2603p AD=0.2603p
+ PS=1.75u PD=1.75u
M$28 \$19 \$I1772 \$15 \$I3 sg13_lv_pmos L=0.35u W=1.37u AS=0.2603p AD=0.2603p
+ PS=1.75u PD=1.75u
M$29 \$15 \$I1773 \$8 \$I3 sg13_lv_pmos L=0.35u W=1.37u AS=0.2603p AD=0.2603p
+ PS=1.75u PD=1.75u
M$30 \$8 \$I1981 \$3 \$I3 sg13_lv_pmos L=0.35u W=1.37u AS=0.2603p AD=0.4658p
+ PS=1.75u PD=3.42u
M$31 \$2 \$I828 \$1 \$I3 sg13_lv_pmos L=0.35u W=1.37u AS=0.4658p AD=0.2603p
+ PS=3.42u PD=1.75u
M$32 \$1 \$I1751 \$9 \$I3 sg13_lv_pmos L=0.35u W=1.37u AS=0.2603p AD=0.2603p
+ PS=1.75u PD=1.75u
M$33 \$9 \$I1752 \$7 \$I3 sg13_lv_pmos L=0.35u W=1.37u AS=0.2603p AD=0.2603p
+ PS=1.75u PD=1.75u
M$34 \$7 \$I1753 \$14 \$I3 sg13_lv_pmos L=0.35u W=1.37u AS=0.2603p AD=0.2603p
+ PS=1.75u PD=1.75u
M$35 \$14 \$I1703 \$13 \$I3 sg13_lv_pmos L=0.35u W=1.37u AS=0.2603p AD=0.2603p
+ PS=1.75u PD=1.75u
M$36 \$13 \$I1705 \$20 \$I3 sg13_lv_pmos L=0.35u W=1.37u AS=0.2603p AD=0.2603p
+ PS=1.75u PD=1.75u
M$37 \$20 \$I1771 \$19 \$I3 sg13_lv_pmos L=0.35u W=1.37u AS=0.2603p AD=0.2603p
+ PS=1.75u PD=1.75u
M$38 \$19 \$I1772 \$15 \$I3 sg13_lv_pmos L=0.35u W=1.37u AS=0.2603p AD=0.2603p
+ PS=1.75u PD=1.75u
M$39 \$15 \$I1773 \$8 \$I3 sg13_lv_pmos L=0.35u W=1.37u AS=0.2603p AD=0.2603p
+ PS=1.75u PD=1.75u
M$40 \$8 \$I1981 \$3 \$I3 sg13_lv_pmos L=0.35u W=1.37u AS=0.2603p AD=0.4658p
+ PS=1.75u PD=3.42u
M$41 \$2 \$I828 \$1 \$I3 sg13_lv_pmos L=0.35u W=1.37u AS=0.4658p AD=0.2603p
+ PS=3.42u PD=1.75u
M$42 \$1 \$I1751 \$9 \$I3 sg13_lv_pmos L=0.35u W=1.37u AS=0.2603p AD=0.2603p
+ PS=1.75u PD=1.75u
M$43 \$9 \$I1752 \$7 \$I3 sg13_lv_pmos L=0.35u W=1.37u AS=0.2603p AD=0.2603p
+ PS=1.75u PD=1.75u
M$44 \$7 \$I1753 \$14 \$I3 sg13_lv_pmos L=0.35u W=1.37u AS=0.2603p AD=0.2603p
+ PS=1.75u PD=1.75u
M$45 \$14 \$I1703 \$13 \$I3 sg13_lv_pmos L=0.35u W=1.37u AS=0.2603p AD=0.2603p
+ PS=1.75u PD=1.75u
M$46 \$13 \$I1705 \$20 \$I3 sg13_lv_pmos L=0.35u W=1.37u AS=0.2603p AD=0.2603p
+ PS=1.75u PD=1.75u
M$47 \$20 \$I1771 \$19 \$I3 sg13_lv_pmos L=0.35u W=1.37u AS=0.2603p AD=0.2603p
+ PS=1.75u PD=1.75u
M$48 \$19 \$I1772 \$15 \$I3 sg13_lv_pmos L=0.35u W=1.37u AS=0.2603p AD=0.2603p
+ PS=1.75u PD=1.75u
M$49 \$15 \$I1773 \$8 \$I3 sg13_lv_pmos L=0.35u W=1.37u AS=0.2603p AD=0.2603p
+ PS=1.75u PD=1.75u
M$50 \$8 \$I1981 \$3 \$I3 sg13_lv_pmos L=0.35u W=1.37u AS=0.2603p AD=0.4658p
+ PS=1.75u PD=3.42u
M$51 \$2 \$I828 \$1 \$I3 sg13_lv_pmos L=0.35u W=1.37u AS=0.4658p AD=0.2603p
+ PS=3.42u PD=1.75u
M$52 \$1 \$I1751 \$9 \$I3 sg13_lv_pmos L=0.35u W=1.37u AS=0.2603p AD=0.2603p
+ PS=1.75u PD=1.75u
M$53 \$9 \$I1752 \$7 \$I3 sg13_lv_pmos L=0.35u W=1.37u AS=0.2603p AD=0.2603p
+ PS=1.75u PD=1.75u
M$54 \$7 \$I1753 \$14 \$I3 sg13_lv_pmos L=0.35u W=1.37u AS=0.2603p AD=0.2603p
+ PS=1.75u PD=1.75u
M$55 \$14 \$I1703 \$13 \$I3 sg13_lv_pmos L=0.35u W=1.37u AS=0.2603p AD=0.2603p
+ PS=1.75u PD=1.75u
M$56 \$13 \$I1705 \$20 \$I3 sg13_lv_pmos L=0.35u W=1.37u AS=0.2603p AD=0.2603p
+ PS=1.75u PD=1.75u
M$57 \$20 \$I1771 \$19 \$I3 sg13_lv_pmos L=0.35u W=1.37u AS=0.2603p AD=0.2603p
+ PS=1.75u PD=1.75u
M$58 \$19 \$I1772 \$15 \$I3 sg13_lv_pmos L=0.35u W=1.37u AS=0.2603p AD=0.2603p
+ PS=1.75u PD=1.75u
M$59 \$15 \$I1773 \$8 \$I3 sg13_lv_pmos L=0.35u W=1.37u AS=0.2603p AD=0.2603p
+ PS=1.75u PD=1.75u
M$60 \$8 \$I1981 \$3 \$I3 sg13_lv_pmos L=0.35u W=1.37u AS=0.2603p AD=0.4658p
+ PS=1.75u PD=3.42u
M$61 \$2 \$I828 \$1 \$I3 sg13_lv_pmos L=0.35u W=1.37u AS=0.4658p AD=0.2603p
+ PS=3.42u PD=1.75u
M$62 \$1 \$I1751 \$9 \$I3 sg13_lv_pmos L=0.35u W=1.37u AS=0.2603p AD=0.2603p
+ PS=1.75u PD=1.75u
M$63 \$9 \$I1752 \$7 \$I3 sg13_lv_pmos L=0.35u W=1.37u AS=0.2603p AD=0.2603p
+ PS=1.75u PD=1.75u
M$64 \$7 \$I1753 \$14 \$I3 sg13_lv_pmos L=0.35u W=1.37u AS=0.2603p AD=0.2603p
+ PS=1.75u PD=1.75u
M$65 \$14 \$I1703 \$13 \$I3 sg13_lv_pmos L=0.35u W=1.37u AS=0.2603p AD=0.2603p
+ PS=1.75u PD=1.75u
M$66 \$13 \$I1705 \$20 \$I3 sg13_lv_pmos L=0.35u W=1.37u AS=0.2603p AD=0.2603p
+ PS=1.75u PD=1.75u
M$67 \$20 \$I1771 \$19 \$I3 sg13_lv_pmos L=0.35u W=1.37u AS=0.2603p AD=0.2603p
+ PS=1.75u PD=1.75u
M$68 \$19 \$I1772 \$15 \$I3 sg13_lv_pmos L=0.35u W=1.37u AS=0.2603p AD=0.2603p
+ PS=1.75u PD=1.75u
M$69 \$15 \$I1773 \$8 \$I3 sg13_lv_pmos L=0.35u W=1.37u AS=0.2603p AD=0.2603p
+ PS=1.75u PD=1.75u
M$70 \$8 \$I1981 \$3 \$I3 sg13_lv_pmos L=0.35u W=1.37u AS=0.2603p AD=0.4658p
+ PS=1.75u PD=3.42u
M$71 \$2 \$I828 \$1 \$I3 sg13_lv_pmos L=0.35u W=1.37u AS=0.4658p AD=0.2603p
+ PS=3.42u PD=1.75u
M$72 \$1 \$I1751 \$9 \$I3 sg13_lv_pmos L=0.35u W=1.37u AS=0.2603p AD=0.2603p
+ PS=1.75u PD=1.75u
M$73 \$9 \$I1752 \$7 \$I3 sg13_lv_pmos L=0.35u W=1.37u AS=0.2603p AD=0.2603p
+ PS=1.75u PD=1.75u
M$74 \$7 \$I1753 \$14 \$I3 sg13_lv_pmos L=0.35u W=1.37u AS=0.2603p AD=0.2603p
+ PS=1.75u PD=1.75u
M$75 \$14 \$I1703 \$13 \$I3 sg13_lv_pmos L=0.35u W=1.37u AS=0.2603p AD=0.2603p
+ PS=1.75u PD=1.75u
M$76 \$13 \$I1705 \$20 \$I3 sg13_lv_pmos L=0.35u W=1.37u AS=0.2603p AD=0.2603p
+ PS=1.75u PD=1.75u
M$77 \$20 \$I1771 \$19 \$I3 sg13_lv_pmos L=0.35u W=1.37u AS=0.2603p AD=0.2603p
+ PS=1.75u PD=1.75u
M$78 \$19 \$I1772 \$15 \$I3 sg13_lv_pmos L=0.35u W=1.37u AS=0.2603p AD=0.2603p
+ PS=1.75u PD=1.75u
M$79 \$15 \$I1773 \$8 \$I3 sg13_lv_pmos L=0.35u W=1.37u AS=0.2603p AD=0.2603p
+ PS=1.75u PD=1.75u
M$80 \$8 \$I1981 \$3 \$I3 sg13_lv_pmos L=0.35u W=1.37u AS=0.2603p AD=0.4658p
+ PS=1.75u PD=3.42u
M$81 \$2 \$I828 \$1 \$I3 sg13_lv_pmos L=0.35u W=1.37u AS=0.4658p AD=0.2603p
+ PS=3.42u PD=1.75u
M$82 \$1 \$I1751 \$9 \$I3 sg13_lv_pmos L=0.35u W=1.37u AS=0.2603p AD=0.2603p
+ PS=1.75u PD=1.75u
M$83 \$9 \$I1752 \$7 \$I3 sg13_lv_pmos L=0.35u W=1.37u AS=0.2603p AD=0.2603p
+ PS=1.75u PD=1.75u
M$84 \$7 \$I1753 \$14 \$I3 sg13_lv_pmos L=0.35u W=1.37u AS=0.2603p AD=0.2603p
+ PS=1.75u PD=1.75u
M$85 \$14 \$I1703 \$13 \$I3 sg13_lv_pmos L=0.35u W=1.37u AS=0.2603p AD=0.2603p
+ PS=1.75u PD=1.75u
M$86 \$13 \$I1705 \$20 \$I3 sg13_lv_pmos L=0.35u W=1.37u AS=0.2603p AD=0.2603p
+ PS=1.75u PD=1.75u
M$87 \$20 \$I1771 \$19 \$I3 sg13_lv_pmos L=0.35u W=1.37u AS=0.2603p AD=0.2603p
+ PS=1.75u PD=1.75u
M$88 \$19 \$I1772 \$15 \$I3 sg13_lv_pmos L=0.35u W=1.37u AS=0.2603p AD=0.2603p
+ PS=1.75u PD=1.75u
M$89 \$15 \$I1773 \$8 \$I3 sg13_lv_pmos L=0.35u W=1.37u AS=0.2603p AD=0.2603p
+ PS=1.75u PD=1.75u
M$90 \$8 \$I1981 \$3 \$I3 sg13_lv_pmos L=0.35u W=1.37u AS=0.2603p AD=0.4658p
+ PS=1.75u PD=3.42u
M$91 \$2 \$I828 \$1 \$I3 sg13_lv_pmos L=0.35u W=1.37u AS=0.4658p AD=0.2603p
+ PS=3.42u PD=1.75u
M$92 \$1 \$I1751 \$9 \$I3 sg13_lv_pmos L=0.35u W=1.37u AS=0.2603p AD=0.2603p
+ PS=1.75u PD=1.75u
M$93 \$9 \$I1752 \$7 \$I3 sg13_lv_pmos L=0.35u W=1.37u AS=0.2603p AD=0.2603p
+ PS=1.75u PD=1.75u
M$94 \$7 \$I1753 \$14 \$I3 sg13_lv_pmos L=0.35u W=1.37u AS=0.2603p AD=0.2603p
+ PS=1.75u PD=1.75u
M$95 \$14 \$I1703 \$13 \$I3 sg13_lv_pmos L=0.35u W=1.37u AS=0.2603p AD=0.2603p
+ PS=1.75u PD=1.75u
M$96 \$13 \$I1705 \$20 \$I3 sg13_lv_pmos L=0.35u W=1.37u AS=0.2603p AD=0.2603p
+ PS=1.75u PD=1.75u
M$97 \$20 \$I1771 \$19 \$I3 sg13_lv_pmos L=0.35u W=1.37u AS=0.2603p AD=0.2603p
+ PS=1.75u PD=1.75u
M$98 \$19 \$I1772 \$15 \$I3 sg13_lv_pmos L=0.35u W=1.37u AS=0.2603p AD=0.2603p
+ PS=1.75u PD=1.75u
M$99 \$15 \$I1773 \$8 \$I3 sg13_lv_pmos L=0.35u W=1.37u AS=0.2603p AD=0.2603p
+ PS=1.75u PD=1.75u
M$100 \$8 \$I1981 \$3 \$I3 sg13_lv_pmos L=0.35u W=1.37u AS=0.2603p AD=0.4658p
+ PS=1.75u PD=3.42u
M$101 \$2 \$I828 \$1 \$I3 sg13_lv_pmos L=0.35u W=1.37u AS=0.4658p AD=0.2603p
+ PS=3.42u PD=1.75u
M$102 \$1 \$I1751 \$9 \$I3 sg13_lv_pmos L=0.35u W=1.37u AS=0.2603p AD=0.2603p
+ PS=1.75u PD=1.75u
M$103 \$9 \$I1752 \$7 \$I3 sg13_lv_pmos L=0.35u W=1.37u AS=0.2603p AD=0.2603p
+ PS=1.75u PD=1.75u
M$104 \$7 \$I1753 \$14 \$I3 sg13_lv_pmos L=0.35u W=1.37u AS=0.2603p AD=0.2603p
+ PS=1.75u PD=1.75u
M$105 \$14 \$I1703 \$13 \$I3 sg13_lv_pmos L=0.35u W=1.37u AS=0.2603p AD=0.2603p
+ PS=1.75u PD=1.75u
M$106 \$13 \$I1705 \$20 \$I3 sg13_lv_pmos L=0.35u W=1.37u AS=0.2603p AD=0.2603p
+ PS=1.75u PD=1.75u
M$107 \$20 \$I1771 \$19 \$I3 sg13_lv_pmos L=0.35u W=1.37u AS=0.2603p AD=0.2603p
+ PS=1.75u PD=1.75u
M$108 \$19 \$I1772 \$15 \$I3 sg13_lv_pmos L=0.35u W=1.37u AS=0.2603p AD=0.2603p
+ PS=1.75u PD=1.75u
M$109 \$15 \$I1773 \$8 \$I3 sg13_lv_pmos L=0.35u W=1.37u AS=0.2603p AD=0.2603p
+ PS=1.75u PD=1.75u
M$110 \$8 \$I1981 \$3 \$I3 sg13_lv_pmos L=0.35u W=1.37u AS=0.2603p AD=0.4658p
+ PS=1.75u PD=3.42u
M$111 \$2 \$I828 \$1 \$I3 sg13_lv_pmos L=0.35u W=1.37u AS=0.4658p AD=0.2603p
+ PS=3.42u PD=1.75u
M$112 \$1 \$I1751 \$9 \$I3 sg13_lv_pmos L=0.35u W=1.37u AS=0.2603p AD=0.2603p
+ PS=1.75u PD=1.75u
M$113 \$9 \$I1752 \$7 \$I3 sg13_lv_pmos L=0.35u W=1.37u AS=0.2603p AD=0.2603p
+ PS=1.75u PD=1.75u
M$114 \$7 \$I1753 \$14 \$I3 sg13_lv_pmos L=0.35u W=1.37u AS=0.2603p AD=0.2603p
+ PS=1.75u PD=1.75u
M$115 \$14 \$I1703 \$13 \$I3 sg13_lv_pmos L=0.35u W=1.37u AS=0.2603p AD=0.2603p
+ PS=1.75u PD=1.75u
M$116 \$13 \$I1705 \$20 \$I3 sg13_lv_pmos L=0.35u W=1.37u AS=0.2603p AD=0.2603p
+ PS=1.75u PD=1.75u
M$117 \$20 \$I1771 \$19 \$I3 sg13_lv_pmos L=0.35u W=1.37u AS=0.2603p AD=0.2603p
+ PS=1.75u PD=1.75u
M$118 \$19 \$I1772 \$15 \$I3 sg13_lv_pmos L=0.35u W=1.37u AS=0.2603p AD=0.2603p
+ PS=1.75u PD=1.75u
M$119 \$15 \$I1773 \$8 \$I3 sg13_lv_pmos L=0.35u W=1.37u AS=0.2603p AD=0.2603p
+ PS=1.75u PD=1.75u
M$120 \$8 \$I1981 \$3 \$I3 sg13_lv_pmos L=0.35u W=1.37u AS=0.2603p AD=0.4658p
+ PS=1.75u PD=3.42u
M$121 \$2 \$I828 \$1 \$I3 sg13_lv_pmos L=0.35u W=1.37u AS=0.4658p AD=0.2603p
+ PS=3.42u PD=1.75u
M$122 \$1 \$I1751 \$9 \$I3 sg13_lv_pmos L=0.35u W=1.37u AS=0.2603p AD=0.2603p
+ PS=1.75u PD=1.75u
M$123 \$9 \$I1752 \$7 \$I3 sg13_lv_pmos L=0.35u W=1.37u AS=0.2603p AD=0.2603p
+ PS=1.75u PD=1.75u
M$124 \$7 \$I1753 \$14 \$I3 sg13_lv_pmos L=0.35u W=1.37u AS=0.2603p AD=0.2603p
+ PS=1.75u PD=1.75u
M$125 \$14 \$I1703 \$13 \$I3 sg13_lv_pmos L=0.35u W=1.37u AS=0.2603p AD=0.2603p
+ PS=1.75u PD=1.75u
M$126 \$13 \$I1705 \$20 \$I3 sg13_lv_pmos L=0.35u W=1.37u AS=0.2603p AD=0.2603p
+ PS=1.75u PD=1.75u
M$127 \$20 \$I1771 \$19 \$I3 sg13_lv_pmos L=0.35u W=1.37u AS=0.2603p AD=0.2603p
+ PS=1.75u PD=1.75u
M$128 \$19 \$I1772 \$15 \$I3 sg13_lv_pmos L=0.35u W=1.37u AS=0.2603p AD=0.2603p
+ PS=1.75u PD=1.75u
M$129 \$15 \$I1773 \$8 \$I3 sg13_lv_pmos L=0.35u W=1.37u AS=0.2603p AD=0.2603p
+ PS=1.75u PD=1.75u
M$130 \$8 \$I1981 \$3 \$I3 sg13_lv_pmos L=0.35u W=1.37u AS=0.2603p AD=0.4658p
+ PS=1.75u PD=3.42u
M$131 \$2 \$I828 \$1 \$I3 sg13_lv_pmos L=0.35u W=1.37u AS=0.4658p AD=0.2603p
+ PS=3.42u PD=1.75u
M$132 \$1 \$I1751 \$9 \$I3 sg13_lv_pmos L=0.35u W=1.37u AS=0.2603p AD=0.2603p
+ PS=1.75u PD=1.75u
M$133 \$9 \$I1752 \$7 \$I3 sg13_lv_pmos L=0.35u W=1.37u AS=0.2603p AD=0.2603p
+ PS=1.75u PD=1.75u
M$134 \$7 \$I1753 \$14 \$I3 sg13_lv_pmos L=0.35u W=1.37u AS=0.2603p AD=0.2603p
+ PS=1.75u PD=1.75u
M$135 \$14 \$I1703 \$13 \$I3 sg13_lv_pmos L=0.35u W=1.37u AS=0.2603p AD=0.2603p
+ PS=1.75u PD=1.75u
M$136 \$13 \$I1705 \$20 \$I3 sg13_lv_pmos L=0.35u W=1.37u AS=0.2603p AD=0.2603p
+ PS=1.75u PD=1.75u
M$137 \$20 \$I1771 \$19 \$I3 sg13_lv_pmos L=0.35u W=1.37u AS=0.2603p AD=0.2603p
+ PS=1.75u PD=1.75u
M$138 \$19 \$I1772 \$15 \$I3 sg13_lv_pmos L=0.35u W=1.37u AS=0.2603p AD=0.2603p
+ PS=1.75u PD=1.75u
M$139 \$15 \$I1773 \$8 \$I3 sg13_lv_pmos L=0.35u W=1.37u AS=0.2603p AD=0.2603p
+ PS=1.75u PD=1.75u
M$140 \$8 \$I1981 \$3 \$I3 sg13_lv_pmos L=0.35u W=1.37u AS=0.2603p AD=0.4658p
+ PS=1.75u PD=3.42u
M$141 \$2 \$I828 \$1 \$I3 sg13_lv_pmos L=0.35u W=1.37u AS=0.4658p AD=0.2603p
+ PS=3.42u PD=1.75u
M$142 \$1 \$I1751 \$9 \$I3 sg13_lv_pmos L=0.35u W=1.37u AS=0.2603p AD=0.2603p
+ PS=1.75u PD=1.75u
M$143 \$9 \$I1752 \$7 \$I3 sg13_lv_pmos L=0.35u W=1.37u AS=0.2603p AD=0.2603p
+ PS=1.75u PD=1.75u
M$144 \$7 \$I1753 \$14 \$I3 sg13_lv_pmos L=0.35u W=1.37u AS=0.2603p AD=0.2603p
+ PS=1.75u PD=1.75u
M$145 \$14 \$I1703 \$13 \$I3 sg13_lv_pmos L=0.35u W=1.37u AS=0.2603p AD=0.2603p
+ PS=1.75u PD=1.75u
M$146 \$13 \$I1705 \$20 \$I3 sg13_lv_pmos L=0.35u W=1.37u AS=0.2603p AD=0.2603p
+ PS=1.75u PD=1.75u
M$147 \$20 \$I1771 \$19 \$I3 sg13_lv_pmos L=0.35u W=1.37u AS=0.2603p AD=0.2603p
+ PS=1.75u PD=1.75u
M$148 \$19 \$I1772 \$15 \$I3 sg13_lv_pmos L=0.35u W=1.37u AS=0.2603p AD=0.2603p
+ PS=1.75u PD=1.75u
M$149 \$15 \$I1773 \$8 \$I3 sg13_lv_pmos L=0.35u W=1.37u AS=0.2603p AD=0.2603p
+ PS=1.75u PD=1.75u
M$150 \$8 \$I1981 \$3 \$I3 sg13_lv_pmos L=0.35u W=1.37u AS=0.2603p AD=0.4658p
+ PS=1.75u PD=3.42u
M$151 \$2 \$I828 \$1 \$I3 sg13_lv_pmos L=0.35u W=1.37u AS=0.4658p AD=0.2603p
+ PS=3.42u PD=1.75u
M$152 \$1 \$I1751 \$9 \$I3 sg13_lv_pmos L=0.35u W=1.37u AS=0.2603p AD=0.2603p
+ PS=1.75u PD=1.75u
M$153 \$9 \$I1752 \$7 \$I3 sg13_lv_pmos L=0.35u W=1.37u AS=0.2603p AD=0.2603p
+ PS=1.75u PD=1.75u
M$154 \$7 \$I1753 \$14 \$I3 sg13_lv_pmos L=0.35u W=1.37u AS=0.2603p AD=0.2603p
+ PS=1.75u PD=1.75u
M$155 \$14 \$I1703 \$13 \$I3 sg13_lv_pmos L=0.35u W=1.37u AS=0.2603p AD=0.2603p
+ PS=1.75u PD=1.75u
M$156 \$13 \$I1705 \$20 \$I3 sg13_lv_pmos L=0.35u W=1.37u AS=0.2603p AD=0.2603p
+ PS=1.75u PD=1.75u
M$157 \$20 \$I1771 \$19 \$I3 sg13_lv_pmos L=0.35u W=1.37u AS=0.2603p AD=0.2603p
+ PS=1.75u PD=1.75u
M$158 \$19 \$I1772 \$15 \$I3 sg13_lv_pmos L=0.35u W=1.37u AS=0.2603p AD=0.2603p
+ PS=1.75u PD=1.75u
M$159 \$15 \$I1773 \$8 \$I3 sg13_lv_pmos L=0.35u W=1.37u AS=0.2603p AD=0.2603p
+ PS=1.75u PD=1.75u
M$160 \$8 \$I1981 \$3 \$I3 sg13_lv_pmos L=0.35u W=1.37u AS=0.2603p AD=0.4658p
+ PS=1.75u PD=3.42u
M$161 \$2 \$I828 \$1 \$I3 sg13_lv_pmos L=0.35u W=1.37u AS=0.4658p AD=0.2603p
+ PS=3.42u PD=1.75u
M$162 \$1 \$I1751 \$9 \$I3 sg13_lv_pmos L=0.35u W=1.37u AS=0.2603p AD=0.2603p
+ PS=1.75u PD=1.75u
M$163 \$9 \$I1752 \$7 \$I3 sg13_lv_pmos L=0.35u W=1.37u AS=0.2603p AD=0.2603p
+ PS=1.75u PD=1.75u
M$164 \$7 \$I1753 \$14 \$I3 sg13_lv_pmos L=0.35u W=1.37u AS=0.2603p AD=0.2603p
+ PS=1.75u PD=1.75u
M$165 \$14 \$I1703 \$13 \$I3 sg13_lv_pmos L=0.35u W=1.37u AS=0.2603p AD=0.2603p
+ PS=1.75u PD=1.75u
M$166 \$13 \$I1705 \$20 \$I3 sg13_lv_pmos L=0.35u W=1.37u AS=0.2603p AD=0.2603p
+ PS=1.75u PD=1.75u
M$167 \$20 \$I1771 \$19 \$I3 sg13_lv_pmos L=0.35u W=1.37u AS=0.2603p AD=0.2603p
+ PS=1.75u PD=1.75u
M$168 \$19 \$I1772 \$15 \$I3 sg13_lv_pmos L=0.35u W=1.37u AS=0.2603p AD=0.2603p
+ PS=1.75u PD=1.75u
M$169 \$15 \$I1773 \$8 \$I3 sg13_lv_pmos L=0.35u W=1.37u AS=0.2603p AD=0.2603p
+ PS=1.75u PD=1.75u
M$170 \$8 \$I1981 \$3 \$I3 sg13_lv_pmos L=0.35u W=1.37u AS=0.2603p AD=0.4658p
+ PS=1.75u PD=3.42u
M$171 \$2 \$I828 \$1 \$I3 sg13_lv_pmos L=0.35u W=1.37u AS=0.4658p AD=0.2603p
+ PS=3.42u PD=1.75u
M$172 \$1 \$I1751 \$9 \$I3 sg13_lv_pmos L=0.35u W=1.37u AS=0.2603p AD=0.2603p
+ PS=1.75u PD=1.75u
M$173 \$9 \$I1752 \$7 \$I3 sg13_lv_pmos L=0.35u W=1.37u AS=0.2603p AD=0.2603p
+ PS=1.75u PD=1.75u
M$174 \$7 \$I1753 \$14 \$I3 sg13_lv_pmos L=0.35u W=1.37u AS=0.2603p AD=0.2603p
+ PS=1.75u PD=1.75u
M$175 \$14 \$I1703 \$13 \$I3 sg13_lv_pmos L=0.35u W=1.37u AS=0.2603p AD=0.2603p
+ PS=1.75u PD=1.75u
M$176 \$13 \$I1705 \$20 \$I3 sg13_lv_pmos L=0.35u W=1.37u AS=0.2603p AD=0.2603p
+ PS=1.75u PD=1.75u
M$177 \$20 \$I1771 \$19 \$I3 sg13_lv_pmos L=0.35u W=1.37u AS=0.2603p AD=0.2603p
+ PS=1.75u PD=1.75u
M$178 \$19 \$I1772 \$15 \$I3 sg13_lv_pmos L=0.35u W=1.37u AS=0.2603p AD=0.2603p
+ PS=1.75u PD=1.75u
M$179 \$15 \$I1773 \$8 \$I3 sg13_lv_pmos L=0.35u W=1.37u AS=0.2603p AD=0.2603p
+ PS=1.75u PD=1.75u
M$180 \$8 \$I1981 \$3 \$I3 sg13_lv_pmos L=0.35u W=1.37u AS=0.2603p AD=0.4658p
+ PS=1.75u PD=3.42u
M$181 \$2 \$I828 \$1 \$I3 sg13_lv_pmos L=0.35u W=1.37u AS=0.4658p AD=0.2603p
+ PS=3.42u PD=1.75u
M$182 \$1 \$I1751 \$9 \$I3 sg13_lv_pmos L=0.35u W=1.37u AS=0.2603p AD=0.2603p
+ PS=1.75u PD=1.75u
M$183 \$9 \$I1752 \$7 \$I3 sg13_lv_pmos L=0.35u W=1.37u AS=0.2603p AD=0.2603p
+ PS=1.75u PD=1.75u
M$184 \$7 \$I1753 \$14 \$I3 sg13_lv_pmos L=0.35u W=1.37u AS=0.2603p AD=0.2603p
+ PS=1.75u PD=1.75u
M$185 \$14 \$I1703 \$13 \$I3 sg13_lv_pmos L=0.35u W=1.37u AS=0.2603p AD=0.2603p
+ PS=1.75u PD=1.75u
M$186 \$13 \$I1705 \$20 \$I3 sg13_lv_pmos L=0.35u W=1.37u AS=0.2603p AD=0.2603p
+ PS=1.75u PD=1.75u
M$187 \$20 \$I1771 \$19 \$I3 sg13_lv_pmos L=0.35u W=1.37u AS=0.2603p AD=0.2603p
+ PS=1.75u PD=1.75u
M$188 \$19 \$I1772 \$15 \$I3 sg13_lv_pmos L=0.35u W=1.37u AS=0.2603p AD=0.2603p
+ PS=1.75u PD=1.75u
M$189 \$15 \$I1773 \$8 \$I3 sg13_lv_pmos L=0.35u W=1.37u AS=0.2603p AD=0.2603p
+ PS=1.75u PD=1.75u
M$190 \$8 \$I1981 \$3 \$I3 sg13_lv_pmos L=0.35u W=1.37u AS=0.2603p AD=0.4658p
+ PS=1.75u PD=3.42u
M$191 \$2 \$I828 \$1 \$I3 sg13_lv_pmos L=0.35u W=1.37u AS=0.4658p AD=0.2603p
+ PS=3.42u PD=1.75u
M$192 \$1 \$I1751 \$9 \$I3 sg13_lv_pmos L=0.35u W=1.37u AS=0.2603p AD=0.2603p
+ PS=1.75u PD=1.75u
M$193 \$9 \$I1752 \$7 \$I3 sg13_lv_pmos L=0.35u W=1.37u AS=0.2603p AD=0.2603p
+ PS=1.75u PD=1.75u
M$194 \$7 \$I1753 \$14 \$I3 sg13_lv_pmos L=0.35u W=1.37u AS=0.2603p AD=0.2603p
+ PS=1.75u PD=1.75u
M$195 \$14 \$I1703 \$13 \$I3 sg13_lv_pmos L=0.35u W=1.37u AS=0.2603p AD=0.2603p
+ PS=1.75u PD=1.75u
M$196 \$13 \$I1705 \$20 \$I3 sg13_lv_pmos L=0.35u W=1.37u AS=0.2603p AD=0.2603p
+ PS=1.75u PD=1.75u
M$197 \$20 \$I1771 \$19 \$I3 sg13_lv_pmos L=0.35u W=1.37u AS=0.2603p AD=0.2603p
+ PS=1.75u PD=1.75u
M$198 \$19 \$I1772 \$15 \$I3 sg13_lv_pmos L=0.35u W=1.37u AS=0.2603p AD=0.2603p
+ PS=1.75u PD=1.75u
M$199 \$15 \$I1773 \$8 \$I3 sg13_lv_pmos L=0.35u W=1.37u AS=0.2603p AD=0.2603p
+ PS=1.75u PD=1.75u
M$200 \$8 \$I1981 \$3 \$I3 sg13_lv_pmos L=0.35u W=1.37u AS=0.2603p AD=0.4658p
+ PS=1.75u PD=3.42u
M$201 \$2 \$I828 \$1 \$I3 sg13_lv_pmos L=0.35u W=1.37u AS=0.4658p AD=0.2603p
+ PS=3.42u PD=1.75u
M$202 \$1 \$I1751 \$9 \$I3 sg13_lv_pmos L=0.35u W=1.37u AS=0.2603p AD=0.2603p
+ PS=1.75u PD=1.75u
M$203 \$9 \$I1752 \$7 \$I3 sg13_lv_pmos L=0.35u W=1.37u AS=0.2603p AD=0.2603p
+ PS=1.75u PD=1.75u
M$204 \$7 \$I1753 \$14 \$I3 sg13_lv_pmos L=0.35u W=1.37u AS=0.2603p AD=0.2603p
+ PS=1.75u PD=1.75u
M$205 \$14 \$I1703 \$13 \$I3 sg13_lv_pmos L=0.35u W=1.37u AS=0.2603p AD=0.2603p
+ PS=1.75u PD=1.75u
M$206 \$13 \$I1705 \$20 \$I3 sg13_lv_pmos L=0.35u W=1.37u AS=0.2603p AD=0.2603p
+ PS=1.75u PD=1.75u
M$207 \$20 \$I1771 \$19 \$I3 sg13_lv_pmos L=0.35u W=1.37u AS=0.2603p AD=0.2603p
+ PS=1.75u PD=1.75u
M$208 \$19 \$I1772 \$15 \$I3 sg13_lv_pmos L=0.35u W=1.37u AS=0.2603p AD=0.2603p
+ PS=1.75u PD=1.75u
M$209 \$15 \$I1773 \$8 \$I3 sg13_lv_pmos L=0.35u W=1.37u AS=0.2603p AD=0.2603p
+ PS=1.75u PD=1.75u
M$210 \$8 \$I1981 \$3 \$I3 sg13_lv_pmos L=0.35u W=1.37u AS=0.2603p AD=0.4658p
+ PS=1.75u PD=3.42u
M$211 \$2 \$I828 \$1 \$I3 sg13_lv_pmos L=0.35u W=1.37u AS=0.4658p AD=0.2603p
+ PS=3.42u PD=1.75u
M$212 \$1 \$I1751 \$9 \$I3 sg13_lv_pmos L=0.35u W=1.37u AS=0.2603p AD=0.2603p
+ PS=1.75u PD=1.75u
M$213 \$9 \$I1752 \$7 \$I3 sg13_lv_pmos L=0.35u W=1.37u AS=0.2603p AD=0.2603p
+ PS=1.75u PD=1.75u
M$214 \$7 \$I1753 \$14 \$I3 sg13_lv_pmos L=0.35u W=1.37u AS=0.2603p AD=0.2603p
+ PS=1.75u PD=1.75u
M$215 \$14 \$I1703 \$13 \$I3 sg13_lv_pmos L=0.35u W=1.37u AS=0.2603p AD=0.2603p
+ PS=1.75u PD=1.75u
M$216 \$13 \$I1705 \$20 \$I3 sg13_lv_pmos L=0.35u W=1.37u AS=0.2603p AD=0.2603p
+ PS=1.75u PD=1.75u
M$217 \$20 \$I1771 \$19 \$I3 sg13_lv_pmos L=0.35u W=1.37u AS=0.2603p AD=0.2603p
+ PS=1.75u PD=1.75u
M$218 \$19 \$I1772 \$15 \$I3 sg13_lv_pmos L=0.35u W=1.37u AS=0.2603p AD=0.2603p
+ PS=1.75u PD=1.75u
M$219 \$15 \$I1773 \$8 \$I3 sg13_lv_pmos L=0.35u W=1.37u AS=0.2603p AD=0.2603p
+ PS=1.75u PD=1.75u
M$220 \$8 \$I1981 \$3 \$I3 sg13_lv_pmos L=0.35u W=1.37u AS=0.2603p AD=0.4658p
+ PS=1.75u PD=3.42u
M$221 \$2 \$I828 \$1 \$I3 sg13_lv_pmos L=0.35u W=1.37u AS=0.4658p AD=0.2603p
+ PS=3.42u PD=1.75u
M$222 \$1 \$I1751 \$9 \$I3 sg13_lv_pmos L=0.35u W=1.37u AS=0.2603p AD=0.2603p
+ PS=1.75u PD=1.75u
M$223 \$9 \$I1752 \$7 \$I3 sg13_lv_pmos L=0.35u W=1.37u AS=0.2603p AD=0.2603p
+ PS=1.75u PD=1.75u
M$224 \$7 \$I1753 \$14 \$I3 sg13_lv_pmos L=0.35u W=1.37u AS=0.2603p AD=0.2603p
+ PS=1.75u PD=1.75u
M$225 \$14 \$I1703 \$13 \$I3 sg13_lv_pmos L=0.35u W=1.37u AS=0.2603p AD=0.2603p
+ PS=1.75u PD=1.75u
M$226 \$13 \$I1705 \$20 \$I3 sg13_lv_pmos L=0.35u W=1.37u AS=0.2603p AD=0.2603p
+ PS=1.75u PD=1.75u
M$227 \$20 \$I1771 \$19 \$I3 sg13_lv_pmos L=0.35u W=1.37u AS=0.2603p AD=0.2603p
+ PS=1.75u PD=1.75u
M$228 \$19 \$I1772 \$15 \$I3 sg13_lv_pmos L=0.35u W=1.37u AS=0.2603p AD=0.2603p
+ PS=1.75u PD=1.75u
M$229 \$15 \$I1773 \$8 \$I3 sg13_lv_pmos L=0.35u W=1.37u AS=0.2603p AD=0.2603p
+ PS=1.75u PD=1.75u
M$230 \$8 \$I1981 \$3 \$I3 sg13_lv_pmos L=0.35u W=1.37u AS=0.2603p AD=0.4658p
+ PS=1.75u PD=3.42u
M$231 \$2 \$I828 \$1 \$I3 sg13_lv_pmos L=0.35u W=1.37u AS=0.4658p AD=0.2603p
+ PS=3.42u PD=1.75u
M$232 \$1 \$I1751 \$9 \$I3 sg13_lv_pmos L=0.35u W=1.37u AS=0.2603p AD=0.2603p
+ PS=1.75u PD=1.75u
M$233 \$9 \$I1752 \$7 \$I3 sg13_lv_pmos L=0.35u W=1.37u AS=0.2603p AD=0.2603p
+ PS=1.75u PD=1.75u
M$234 \$7 \$I1753 \$14 \$I3 sg13_lv_pmos L=0.35u W=1.37u AS=0.2603p AD=0.2603p
+ PS=1.75u PD=1.75u
M$235 \$14 \$I1703 \$13 \$I3 sg13_lv_pmos L=0.35u W=1.37u AS=0.2603p AD=0.2603p
+ PS=1.75u PD=1.75u
M$236 \$13 \$I1705 \$20 \$I3 sg13_lv_pmos L=0.35u W=1.37u AS=0.2603p AD=0.2603p
+ PS=1.75u PD=1.75u
M$237 \$20 \$I1771 \$19 \$I3 sg13_lv_pmos L=0.35u W=1.37u AS=0.2603p AD=0.2603p
+ PS=1.75u PD=1.75u
M$238 \$19 \$I1772 \$15 \$I3 sg13_lv_pmos L=0.35u W=1.37u AS=0.2603p AD=0.2603p
+ PS=1.75u PD=1.75u
M$239 \$15 \$I1773 \$8 \$I3 sg13_lv_pmos L=0.35u W=1.37u AS=0.2603p AD=0.2603p
+ PS=1.75u PD=1.75u
M$240 \$8 \$I1981 \$3 \$I3 sg13_lv_pmos L=0.35u W=1.37u AS=0.2603p AD=0.4658p
+ PS=1.75u PD=3.42u
M$241 \$2 \$I828 \$1 \$I3 sg13_lv_pmos L=0.35u W=1.37u AS=0.4658p AD=0.2603p
+ PS=3.42u PD=1.75u
M$242 \$1 \$I1751 \$9 \$I3 sg13_lv_pmos L=0.35u W=1.37u AS=0.2603p AD=0.2603p
+ PS=1.75u PD=1.75u
M$243 \$9 \$I1752 \$7 \$I3 sg13_lv_pmos L=0.35u W=1.37u AS=0.2603p AD=0.2603p
+ PS=1.75u PD=1.75u
M$244 \$7 \$I1753 \$14 \$I3 sg13_lv_pmos L=0.35u W=1.37u AS=0.2603p AD=0.2603p
+ PS=1.75u PD=1.75u
M$245 \$14 \$I1703 \$13 \$I3 sg13_lv_pmos L=0.35u W=1.37u AS=0.2603p AD=0.2603p
+ PS=1.75u PD=1.75u
M$246 \$13 \$I1705 \$20 \$I3 sg13_lv_pmos L=0.35u W=1.37u AS=0.2603p AD=0.2603p
+ PS=1.75u PD=1.75u
M$247 \$20 \$I1771 \$19 \$I3 sg13_lv_pmos L=0.35u W=1.37u AS=0.2603p AD=0.2603p
+ PS=1.75u PD=1.75u
M$248 \$19 \$I1772 \$15 \$I3 sg13_lv_pmos L=0.35u W=1.37u AS=0.2603p AD=0.2603p
+ PS=1.75u PD=1.75u
M$249 \$15 \$I1773 \$8 \$I3 sg13_lv_pmos L=0.35u W=1.37u AS=0.2603p AD=0.2603p
+ PS=1.75u PD=1.75u
M$250 \$8 \$I1981 \$3 \$I3 sg13_lv_pmos L=0.35u W=1.37u AS=0.2603p AD=0.4658p
+ PS=1.75u PD=3.42u
.ENDS M9M10

.SUBCKT sourceRowM5M6 \$1 \$2
X$1 \$1 \$2 via_stack$1
X$2 \$1 \$2 via_stack$1
X$3 \$1 \$2 via_stack$1
.ENDS sourceRowM5M6

.SUBCKT gateM5M6 \$1 \$2
X$1 \$2 \$1 via_stack$8
.ENDS gateM5M6

.SUBCKT drainRowM5M6 \$1 \$2
X$1 \$1 \$2 via_stack$1
X$2 \$1 \$2 via_stack$1
X$3 \$1 \$2 via_stack$1
X$4 \$1 \$2 via_stack$1
.ENDS drainRowM5M6

.SUBCKT M5M6 \$1 \$2 \$3 \$5 \$7 \$13 \$17 \$36 \$I161 \$I156 \$I151 \$I146
+ \$I141 \$I136 \$I103
X$1 \$36 \$1 M1_conM5M6
X$2 \$1 \$13 \$I103 \$36 \$I141 pmos$2
X$3 \$1 \$13 \$I103 \$36 \$I141 pmos$2
X$4 \$17 \$1 \$I103 \$36 \$I136 pmos$2
X$5 \$17 \$1 \$I103 \$36 \$I136 pmos$2
X$6 \$36 \$1 M1_conM5M6
X$7 \$1 \$13 \$I103 \$36 \$I141 pmos$2
X$8 \$17 \$1 \$I103 \$36 \$I136 pmos$2
X$9 \$36 \$1 M1_conM5M6
X$10 \$1 \$13 \$I103 \$36 \$I141 pmos$2
X$11 \$17 \$1 \$I103 \$36 \$I136 pmos$2
X$12 \$36 \$1 M1_conM5M6
X$13 \$1 \$13 \$I103 \$36 \$I141 pmos$2
X$14 \$17 \$1 \$I103 \$36 \$I136 pmos$2
X$15 \$36 \$2 M1_conM5M6
X$16 \$2 \$7 \$I103 \$36 \$I161 pmos$2
X$17 \$2 \$7 \$I103 \$36 \$I161 pmos$2
X$18 \$3 \$2 \$I103 \$36 \$I156 pmos$2
X$19 \$3 \$2 \$I103 \$36 \$I156 pmos$2
X$20 \$36 \$2 M1_conM5M6
X$21 \$2 \$7 \$I103 \$36 \$I161 pmos$2
X$22 \$3 \$2 \$I103 \$36 \$I156 pmos$2
X$23 \$36 \$2 M1_conM5M6
X$24 \$2 \$7 \$I103 \$36 \$I161 pmos$2
X$25 \$3 \$2 \$I103 \$36 \$I156 pmos$2
X$26 \$36 \$2 M1_conM5M6
X$27 \$2 \$7 \$I103 \$36 \$I161 pmos$2
X$28 \$3 \$2 \$I103 \$36 \$I156 pmos$2
X$29 \$36 \$3 M1_conM5M6
X$30 \$5 \$3 \$I103 \$36 \$I151 pmos$2
X$31 \$5 \$3 \$I103 \$36 \$I151 pmos$2
X$32 \$36 \$3 M1_conM5M6
X$33 \$5 \$3 \$I103 \$36 \$I151 pmos$2
X$34 \$36 \$3 M1_conM5M6
X$35 \$5 \$3 \$I103 \$36 \$I151 pmos$2
X$36 \$36 \$3 M1_conM5M6
X$37 \$5 \$3 \$I103 \$36 \$I151 pmos$2
X$38 \$36 \$5 M1_conM5M6
X$39 \$13 \$5 \$I103 \$36 \$I146 pmos$2
X$40 \$13 \$5 \$I103 \$36 \$I146 pmos$2
X$41 \$36 \$5 M1_conM5M6
X$42 \$13 \$5 \$I103 \$36 \$I146 pmos$2
X$43 \$36 \$5 M1_conM5M6
X$44 \$13 \$5 \$I103 \$36 \$I146 pmos$2
X$45 \$36 \$5 M1_conM5M6
X$46 \$13 \$5 \$I103 \$36 \$I146 pmos$2
X$47 \$36 \$7 M1_conM5M6
X$48 \$36 \$7 M1_conM5M6
X$49 \$36 \$7 M1_conM5M6
X$50 \$36 \$7 M1_conM5M6
X$51 \$36 \$13 M1_conM5M6
X$52 \$36 \$13 M1_conM5M6
X$53 \$36 \$13 M1_conM5M6
X$54 \$36 \$13 M1_conM5M6
X$55 \$36 \$17 M1_conM5M6
X$56 \$36 \$17 M1_conM5M6
X$57 \$36 \$17 M1_conM5M6
X$58 \$36 \$17 M1_conM5M6
M$1 \$17 \$I136 \$1 \$I103 sg13_lv_pmos L=0.5u W=4.05u AS=1.377p AD=0.7695p
+ PS=8.78u PD=4.43u
M$2 \$1 \$I141 \$13 \$I103 sg13_lv_pmos L=0.5u W=4.05u AS=0.7695p AD=0.7695p
+ PS=4.43u PD=4.43u
M$3 \$13 \$I146 \$5 \$I103 sg13_lv_pmos L=0.5u W=4.05u AS=0.7695p AD=0.7695p
+ PS=4.43u PD=4.43u
M$4 \$5 \$I151 \$3 \$I103 sg13_lv_pmos L=0.5u W=4.05u AS=0.7695p AD=0.7695p
+ PS=4.43u PD=4.43u
M$5 \$3 \$I156 \$2 \$I103 sg13_lv_pmos L=0.5u W=4.05u AS=0.7695p AD=0.7695p
+ PS=4.43u PD=4.43u
M$6 \$2 \$I161 \$7 \$I103 sg13_lv_pmos L=0.5u W=4.05u AS=0.7695p AD=1.377p
+ PS=4.43u PD=8.78u
M$7 \$17 \$I136 \$1 \$I103 sg13_lv_pmos L=0.5u W=4.05u AS=1.377p AD=0.7695p
+ PS=8.78u PD=4.43u
M$8 \$1 \$I141 \$13 \$I103 sg13_lv_pmos L=0.5u W=4.05u AS=0.7695p AD=0.7695p
+ PS=4.43u PD=4.43u
M$9 \$13 \$I146 \$5 \$I103 sg13_lv_pmos L=0.5u W=4.05u AS=0.7695p AD=0.7695p
+ PS=4.43u PD=4.43u
M$10 \$5 \$I151 \$3 \$I103 sg13_lv_pmos L=0.5u W=4.05u AS=0.7695p AD=0.7695p
+ PS=4.43u PD=4.43u
M$11 \$3 \$I156 \$2 \$I103 sg13_lv_pmos L=0.5u W=4.05u AS=0.7695p AD=0.7695p
+ PS=4.43u PD=4.43u
M$12 \$2 \$I161 \$7 \$I103 sg13_lv_pmos L=0.5u W=4.05u AS=0.7695p AD=1.377p
+ PS=4.43u PD=8.78u
M$13 \$17 \$I136 \$1 \$I103 sg13_lv_pmos L=0.5u W=4.05u AS=1.377p AD=0.7695p
+ PS=8.78u PD=4.43u
M$14 \$1 \$I141 \$13 \$I103 sg13_lv_pmos L=0.5u W=4.05u AS=0.7695p AD=0.7695p
+ PS=4.43u PD=4.43u
M$15 \$13 \$I146 \$5 \$I103 sg13_lv_pmos L=0.5u W=4.05u AS=0.7695p AD=0.7695p
+ PS=4.43u PD=4.43u
M$16 \$5 \$I151 \$3 \$I103 sg13_lv_pmos L=0.5u W=4.05u AS=0.7695p AD=0.7695p
+ PS=4.43u PD=4.43u
M$17 \$3 \$I156 \$2 \$I103 sg13_lv_pmos L=0.5u W=4.05u AS=0.7695p AD=0.7695p
+ PS=4.43u PD=4.43u
M$18 \$2 \$I161 \$7 \$I103 sg13_lv_pmos L=0.5u W=4.05u AS=0.7695p AD=1.377p
+ PS=4.43u PD=8.78u
M$19 \$17 \$I136 \$1 \$I103 sg13_lv_pmos L=0.5u W=4.05u AS=1.377p AD=0.7695p
+ PS=8.78u PD=4.43u
M$20 \$1 \$I141 \$13 \$I103 sg13_lv_pmos L=0.5u W=4.05u AS=0.7695p AD=0.7695p
+ PS=4.43u PD=4.43u
M$21 \$13 \$I146 \$5 \$I103 sg13_lv_pmos L=0.5u W=4.05u AS=0.7695p AD=0.7695p
+ PS=4.43u PD=4.43u
M$22 \$5 \$I151 \$3 \$I103 sg13_lv_pmos L=0.5u W=4.05u AS=0.7695p AD=0.7695p
+ PS=4.43u PD=4.43u
M$23 \$3 \$I156 \$2 \$I103 sg13_lv_pmos L=0.5u W=4.05u AS=0.7695p AD=0.7695p
+ PS=4.43u PD=4.43u
M$24 \$2 \$I161 \$7 \$I103 sg13_lv_pmos L=0.5u W=4.05u AS=0.7695p AD=1.377p
+ PS=4.43u PD=8.78u
M$25 \$17 \$I136 \$1 \$I103 sg13_lv_pmos L=0.5u W=4.05u AS=1.377p AD=0.7695p
+ PS=8.78u PD=4.43u
M$26 \$1 \$I141 \$13 \$I103 sg13_lv_pmos L=0.5u W=4.05u AS=0.7695p AD=0.7695p
+ PS=4.43u PD=4.43u
M$27 \$13 \$I146 \$5 \$I103 sg13_lv_pmos L=0.5u W=4.05u AS=0.7695p AD=0.7695p
+ PS=4.43u PD=4.43u
M$28 \$5 \$I151 \$3 \$I103 sg13_lv_pmos L=0.5u W=4.05u AS=0.7695p AD=0.7695p
+ PS=4.43u PD=4.43u
M$29 \$3 \$I156 \$2 \$I103 sg13_lv_pmos L=0.5u W=4.05u AS=0.7695p AD=0.7695p
+ PS=4.43u PD=4.43u
M$30 \$2 \$I161 \$7 \$I103 sg13_lv_pmos L=0.5u W=4.05u AS=0.7695p AD=1.377p
+ PS=4.43u PD=8.78u
.ENDS M5M6

.SUBCKT sourceRowM7M8 \$1 \$2
X$1 \$1 \$2 via_stack$1
X$2 \$1 \$2 via_stack$1
X$3 \$1 \$2 via_stack$1
.ENDS sourceRowM7M8

.SUBCKT gateM7M8 \$1 \$2
X$1 \$2 \$1 via_stack$9
.ENDS gateM7M8

.SUBCKT drainRowM7M8 \$1 \$2
X$1 \$1 \$2 via_stack$1
X$2 \$1 \$2 via_stack$1
X$3 \$1 \$2 via_stack$1
X$4 \$1 \$2 via_stack$1
.ENDS drainRowM7M8

.SUBCKT M7M8 \$1 \$3 \$4 \$5 \$7 \$12 \$15 \$36 \$I161 \$I156 \$I151 \$I146
+ \$I141 \$I136 \$I102
X$1 \$1 \$12 \$I102 \$36 \$I156 pmos$3
X$2 \$36 \$1 M1_conM7M8
X$3 \$1 \$12 \$I102 \$36 \$I156 pmos$3
X$4 \$36 \$1 M1_conM7M8
X$5 \$1 \$12 \$I102 \$36 \$I156 pmos$3
X$6 \$36 \$1 M1_conM7M8
X$7 \$1 \$12 \$I102 \$36 \$I156 pmos$3
X$8 \$36 \$1 M1_conM7M8
X$9 \$1 \$12 \$I102 \$36 \$I156 pmos$3
X$10 \$3 \$1 \$I102 \$36 \$I151 pmos$3
X$11 \$3 \$1 \$I102 \$36 \$I151 pmos$3
X$12 \$3 \$1 \$I102 \$36 \$I151 pmos$3
X$13 \$3 \$1 \$I102 \$36 \$I151 pmos$3
X$14 \$3 \$1 \$I102 \$36 \$I151 pmos$3
X$15 \$36 \$3 M1_conM7M8
X$16 \$36 \$3 M1_conM7M8
X$17 \$36 \$3 M1_conM7M8
X$18 \$36 \$3 M1_conM7M8
X$19 \$4 \$3 \$I102 \$36 \$I146 pmos$3
X$20 \$4 \$3 \$I102 \$36 \$I146 pmos$3
X$21 \$4 \$3 \$I102 \$36 \$I146 pmos$3
X$22 \$4 \$3 \$I102 \$36 \$I146 pmos$3
X$23 \$4 \$3 \$I102 \$36 \$I146 pmos$3
X$24 \$36 \$4 M1_conM7M8
X$25 \$36 \$4 M1_conM7M8
X$26 \$36 \$4 M1_conM7M8
X$27 \$36 \$4 M1_conM7M8
X$28 \$5 \$4 \$I102 \$36 \$I141 pmos$3
X$29 \$5 \$4 \$I102 \$36 \$I141 pmos$3
X$30 \$5 \$4 \$I102 \$36 \$I141 pmos$3
X$31 \$5 \$4 \$I102 \$36 \$I141 pmos$3
X$32 \$5 \$4 \$I102 \$36 \$I141 pmos$3
X$33 \$36 \$5 M1_conM7M8
X$34 \$36 \$5 M1_conM7M8
X$35 \$36 \$5 M1_conM7M8
X$36 \$36 \$5 M1_conM7M8
X$37 \$15 \$5 \$I102 \$36 \$I136 pmos$3
X$38 \$15 \$5 \$I102 \$36 \$I136 pmos$3
X$39 \$15 \$5 \$I102 \$36 \$I136 pmos$3
X$40 \$15 \$5 \$I102 \$36 \$I136 pmos$3
X$41 \$15 \$5 \$I102 \$36 \$I136 pmos$3
X$42 \$12 \$7 \$I102 \$36 \$I161 pmos$3
X$43 \$36 \$7 M1_conM7M8
X$44 \$12 \$7 \$I102 \$36 \$I161 pmos$3
X$45 \$36 \$7 M1_conM7M8
X$46 \$12 \$7 \$I102 \$36 \$I161 pmos$3
X$47 \$36 \$7 M1_conM7M8
X$48 \$12 \$7 \$I102 \$36 \$I161 pmos$3
X$49 \$36 \$7 M1_conM7M8
X$50 \$12 \$7 \$I102 \$36 \$I161 pmos$3
X$51 \$36 \$12 M1_conM7M8
X$52 \$36 \$12 M1_conM7M8
X$53 \$36 \$12 M1_conM7M8
X$54 \$36 \$12 M1_conM7M8
X$55 \$36 \$15 M1_conM7M8
X$56 \$36 \$15 M1_conM7M8
X$57 \$36 \$15 M1_conM7M8
X$58 \$36 \$15 M1_conM7M8
M$1 \$15 \$I136 \$5 \$I102 sg13_lv_pmos L=0.7u W=7u AS=2.38p AD=1.33p PS=14.68u
+ PD=7.38u
M$2 \$5 \$I141 \$4 \$I102 sg13_lv_pmos L=0.7u W=7u AS=1.33p AD=1.33p PS=7.38u
+ PD=7.38u
M$3 \$4 \$I146 \$3 \$I102 sg13_lv_pmos L=0.7u W=7u AS=1.33p AD=1.33p PS=7.38u
+ PD=7.38u
M$4 \$3 \$I151 \$1 \$I102 sg13_lv_pmos L=0.7u W=7u AS=1.33p AD=1.33p PS=7.38u
+ PD=7.38u
M$5 \$1 \$I156 \$12 \$I102 sg13_lv_pmos L=0.7u W=7u AS=1.33p AD=1.33p PS=7.38u
+ PD=7.38u
M$6 \$12 \$I161 \$7 \$I102 sg13_lv_pmos L=0.7u W=7u AS=1.33p AD=2.38p PS=7.38u
+ PD=14.68u
M$7 \$15 \$I136 \$5 \$I102 sg13_lv_pmos L=0.7u W=7u AS=2.38p AD=1.33p PS=14.68u
+ PD=7.38u
M$8 \$5 \$I141 \$4 \$I102 sg13_lv_pmos L=0.7u W=7u AS=1.33p AD=1.33p PS=7.38u
+ PD=7.38u
M$9 \$4 \$I146 \$3 \$I102 sg13_lv_pmos L=0.7u W=7u AS=1.33p AD=1.33p PS=7.38u
+ PD=7.38u
M$10 \$3 \$I151 \$1 \$I102 sg13_lv_pmos L=0.7u W=7u AS=1.33p AD=1.33p PS=7.38u
+ PD=7.38u
M$11 \$1 \$I156 \$12 \$I102 sg13_lv_pmos L=0.7u W=7u AS=1.33p AD=1.33p PS=7.38u
+ PD=7.38u
M$12 \$12 \$I161 \$7 \$I102 sg13_lv_pmos L=0.7u W=7u AS=1.33p AD=2.38p PS=7.38u
+ PD=14.68u
M$13 \$15 \$I136 \$5 \$I102 sg13_lv_pmos L=0.7u W=7u AS=2.38p AD=1.33p
+ PS=14.68u PD=7.38u
M$14 \$5 \$I141 \$4 \$I102 sg13_lv_pmos L=0.7u W=7u AS=1.33p AD=1.33p PS=7.38u
+ PD=7.38u
M$15 \$4 \$I146 \$3 \$I102 sg13_lv_pmos L=0.7u W=7u AS=1.33p AD=1.33p PS=7.38u
+ PD=7.38u
M$16 \$3 \$I151 \$1 \$I102 sg13_lv_pmos L=0.7u W=7u AS=1.33p AD=1.33p PS=7.38u
+ PD=7.38u
M$17 \$1 \$I156 \$12 \$I102 sg13_lv_pmos L=0.7u W=7u AS=1.33p AD=1.33p PS=7.38u
+ PD=7.38u
M$18 \$12 \$I161 \$7 \$I102 sg13_lv_pmos L=0.7u W=7u AS=1.33p AD=2.38p PS=7.38u
+ PD=14.68u
M$19 \$15 \$I136 \$5 \$I102 sg13_lv_pmos L=0.7u W=7u AS=2.38p AD=1.33p
+ PS=14.68u PD=7.38u
M$20 \$5 \$I141 \$4 \$I102 sg13_lv_pmos L=0.7u W=7u AS=1.33p AD=1.33p PS=7.38u
+ PD=7.38u
M$21 \$4 \$I146 \$3 \$I102 sg13_lv_pmos L=0.7u W=7u AS=1.33p AD=1.33p PS=7.38u
+ PD=7.38u
M$22 \$3 \$I151 \$1 \$I102 sg13_lv_pmos L=0.7u W=7u AS=1.33p AD=1.33p PS=7.38u
+ PD=7.38u
M$23 \$1 \$I156 \$12 \$I102 sg13_lv_pmos L=0.7u W=7u AS=1.33p AD=1.33p PS=7.38u
+ PD=7.38u
M$24 \$12 \$I161 \$7 \$I102 sg13_lv_pmos L=0.7u W=7u AS=1.33p AD=2.38p PS=7.38u
+ PD=14.68u
M$25 \$15 \$I136 \$5 \$I102 sg13_lv_pmos L=0.7u W=7u AS=2.38p AD=1.33p
+ PS=14.68u PD=7.38u
M$26 \$5 \$I141 \$4 \$I102 sg13_lv_pmos L=0.7u W=7u AS=1.33p AD=1.33p PS=7.38u
+ PD=7.38u
M$27 \$4 \$I146 \$3 \$I102 sg13_lv_pmos L=0.7u W=7u AS=1.33p AD=1.33p PS=7.38u
+ PD=7.38u
M$28 \$3 \$I151 \$1 \$I102 sg13_lv_pmos L=0.7u W=7u AS=1.33p AD=1.33p PS=7.38u
+ PD=7.38u
M$29 \$1 \$I156 \$12 \$I102 sg13_lv_pmos L=0.7u W=7u AS=1.33p AD=1.33p PS=7.38u
+ PD=7.38u
M$30 \$12 \$I161 \$7 \$I102 sg13_lv_pmos L=0.7u W=7u AS=1.33p AD=2.38p PS=7.38u
+ PD=14.68u
.ENDS M7M8

.SUBCKT sourceRowM3M4 \$1 \$2
X$1 \$2 \$1 via_stack
X$2 \$2 \$1 via_stack
X$3 \$2 \$1 via_stack
X$4 \$2 \$1 via_stack
.ENDS sourceRowM3M4

.SUBCKT topRowM3M4 \$1 \$2
X$1 \$2 \$1 via_stack$1
X$2 \$2 \$1 via_stack$1
X$3 \$2 \$1 via_stack$1
.ENDS topRowM3M4

.SUBCKT gateM3M4 \$1 \$2
X$1 \$2 \$1 via_stack$7
.ENDS gateM3M4

.SUBCKT drainRowM3M4 \$1 \$2
X$1 \$2 \$1 via_stack$1
X$2 \$2 \$1 via_stack$1
X$3 \$2 \$1 via_stack$1
.ENDS drainRowM3M4

.SUBCKT M3M4 \$1 \$2 \$3 \$4 \$5 \$6 \$11 \$12 \$I131 \$I126 \$I121 \$I116
+ \$I111 \$I106
X$1 \$12 \$3 \$1 \$I106 nmos$2
X$2 \$1 \$12 M1_conM3M4
X$3 \$1 \$3 M1_conM3M4
X$4 \$3 \$4 \$1 \$I111 nmos$2
X$5 \$1 \$4 M1_conM3M4
X$6 \$4 \$2 \$1 \$I116 nmos$2
X$7 \$1 \$2 M1_conM3M4
X$8 \$2 \$6 \$1 \$I121 nmos$2
X$9 \$1 \$6 M1_conM3M4
X$10 \$6 \$5 \$1 \$I126 nmos$2
X$11 \$1 \$5 M1_conM3M4
X$12 \$5 \$11 \$1 \$I131 nmos$2
X$13 \$1 \$11 M1_conM3M4
X$14 \$12 \$3 \$1 \$I106 nmos$2
X$15 \$1 \$12 M1_conM3M4
X$16 \$1 \$3 M1_conM3M4
X$17 \$3 \$4 \$1 \$I111 nmos$2
X$18 \$1 \$4 M1_conM3M4
X$19 \$4 \$2 \$1 \$I116 nmos$2
X$20 \$1 \$2 M1_conM3M4
X$21 \$2 \$6 \$1 \$I121 nmos$2
X$22 \$1 \$6 M1_conM3M4
X$23 \$6 \$5 \$1 \$I126 nmos$2
X$24 \$1 \$5 M1_conM3M4
X$25 \$5 \$11 \$1 \$I131 nmos$2
X$26 \$1 \$11 M1_conM3M4
X$27 \$12 \$3 \$1 \$I106 nmos$2
X$28 \$1 \$12 M1_conM3M4
X$29 \$1 \$3 M1_conM3M4
X$30 \$3 \$4 \$1 \$I111 nmos$2
X$31 \$1 \$4 M1_conM3M4
X$32 \$4 \$2 \$1 \$I116 nmos$2
X$33 \$1 \$2 M1_conM3M4
X$34 \$2 \$6 \$1 \$I121 nmos$2
X$35 \$1 \$6 M1_conM3M4
X$36 \$6 \$5 \$1 \$I126 nmos$2
X$37 \$1 \$5 M1_conM3M4
X$38 \$5 \$11 \$1 \$I131 nmos$2
X$39 \$1 \$11 M1_conM3M4
X$40 \$12 \$3 \$1 \$I106 nmos$2
X$41 \$1 \$12 M1_conM3M4
X$42 \$1 \$3 M1_conM3M4
X$43 \$3 \$4 \$1 \$I111 nmos$2
X$44 \$1 \$4 M1_conM3M4
X$45 \$4 \$2 \$1 \$I116 nmos$2
X$46 \$1 \$2 M1_conM3M4
X$47 \$2 \$6 \$1 \$I121 nmos$2
X$48 \$1 \$6 M1_conM3M4
X$49 \$6 \$5 \$1 \$I126 nmos$2
X$50 \$1 \$5 M1_conM3M4
X$51 \$5 \$11 \$1 \$I131 nmos$2
X$52 \$1 \$11 M1_conM3M4
X$53 \$12 \$3 \$1 \$I106 nmos$2
X$54 \$3 \$4 \$1 \$I111 nmos$2
X$55 \$4 \$2 \$1 \$I116 nmos$2
X$56 \$2 \$6 \$1 \$I121 nmos$2
X$57 \$6 \$5 \$1 \$I126 nmos$2
X$58 \$5 \$11 \$1 \$I131 nmos$2
M$1 \$12 \$I106 \$3 \$1 sg13_lv_nmos L=0.16u W=1.9u AS=0.646p AD=0.361p
+ PS=4.48u PD=2.28u
M$2 \$3 \$I111 \$4 \$1 sg13_lv_nmos L=0.16u W=1.9u AS=0.361p AD=0.361p PS=2.28u
+ PD=2.28u
M$3 \$4 \$I116 \$2 \$1 sg13_lv_nmos L=0.16u W=1.9u AS=0.361p AD=0.361p PS=2.28u
+ PD=2.28u
M$4 \$2 \$I121 \$6 \$1 sg13_lv_nmos L=0.16u W=1.9u AS=0.361p AD=0.361p PS=2.28u
+ PD=2.28u
M$5 \$6 \$I126 \$5 \$1 sg13_lv_nmos L=0.16u W=1.9u AS=0.361p AD=0.361p PS=2.28u
+ PD=2.28u
M$6 \$5 \$I131 \$11 \$1 sg13_lv_nmos L=0.16u W=1.9u AS=0.361p AD=0.646p
+ PS=2.28u PD=4.48u
M$7 \$12 \$I106 \$3 \$1 sg13_lv_nmos L=0.16u W=1.9u AS=0.646p AD=0.361p
+ PS=4.48u PD=2.28u
M$8 \$3 \$I111 \$4 \$1 sg13_lv_nmos L=0.16u W=1.9u AS=0.361p AD=0.361p PS=2.28u
+ PD=2.28u
M$9 \$4 \$I116 \$2 \$1 sg13_lv_nmos L=0.16u W=1.9u AS=0.361p AD=0.361p PS=2.28u
+ PD=2.28u
M$10 \$2 \$I121 \$6 \$1 sg13_lv_nmos L=0.16u W=1.9u AS=0.361p AD=0.361p
+ PS=2.28u PD=2.28u
M$11 \$6 \$I126 \$5 \$1 sg13_lv_nmos L=0.16u W=1.9u AS=0.361p AD=0.361p
+ PS=2.28u PD=2.28u
M$12 \$5 \$I131 \$11 \$1 sg13_lv_nmos L=0.16u W=1.9u AS=0.361p AD=0.646p
+ PS=2.28u PD=4.48u
M$13 \$12 \$I106 \$3 \$1 sg13_lv_nmos L=0.16u W=1.9u AS=0.646p AD=0.361p
+ PS=4.48u PD=2.28u
M$14 \$3 \$I111 \$4 \$1 sg13_lv_nmos L=0.16u W=1.9u AS=0.361p AD=0.361p
+ PS=2.28u PD=2.28u
M$15 \$4 \$I116 \$2 \$1 sg13_lv_nmos L=0.16u W=1.9u AS=0.361p AD=0.361p
+ PS=2.28u PD=2.28u
M$16 \$2 \$I121 \$6 \$1 sg13_lv_nmos L=0.16u W=1.9u AS=0.361p AD=0.361p
+ PS=2.28u PD=2.28u
M$17 \$6 \$I126 \$5 \$1 sg13_lv_nmos L=0.16u W=1.9u AS=0.361p AD=0.361p
+ PS=2.28u PD=2.28u
M$18 \$5 \$I131 \$11 \$1 sg13_lv_nmos L=0.16u W=1.9u AS=0.361p AD=0.646p
+ PS=2.28u PD=4.48u
M$19 \$12 \$I106 \$3 \$1 sg13_lv_nmos L=0.16u W=1.9u AS=0.646p AD=0.361p
+ PS=4.48u PD=2.28u
M$20 \$3 \$I111 \$4 \$1 sg13_lv_nmos L=0.16u W=1.9u AS=0.361p AD=0.361p
+ PS=2.28u PD=2.28u
M$21 \$4 \$I116 \$2 \$1 sg13_lv_nmos L=0.16u W=1.9u AS=0.361p AD=0.361p
+ PS=2.28u PD=2.28u
M$22 \$2 \$I121 \$6 \$1 sg13_lv_nmos L=0.16u W=1.9u AS=0.361p AD=0.361p
+ PS=2.28u PD=2.28u
M$23 \$6 \$I126 \$5 \$1 sg13_lv_nmos L=0.16u W=1.9u AS=0.361p AD=0.361p
+ PS=2.28u PD=2.28u
M$24 \$5 \$I131 \$11 \$1 sg13_lv_nmos L=0.16u W=1.9u AS=0.361p AD=0.646p
+ PS=2.28u PD=4.48u
M$25 \$12 \$I106 \$3 \$1 sg13_lv_nmos L=0.16u W=1.9u AS=0.646p AD=0.361p
+ PS=4.48u PD=2.28u
M$26 \$3 \$I111 \$4 \$1 sg13_lv_nmos L=0.16u W=1.9u AS=0.361p AD=0.361p
+ PS=2.28u PD=2.28u
M$27 \$4 \$I116 \$2 \$1 sg13_lv_nmos L=0.16u W=1.9u AS=0.361p AD=0.361p
+ PS=2.28u PD=2.28u
M$28 \$2 \$I121 \$6 \$1 sg13_lv_nmos L=0.16u W=1.9u AS=0.361p AD=0.361p
+ PS=2.28u PD=2.28u
M$29 \$6 \$I126 \$5 \$1 sg13_lv_nmos L=0.16u W=1.9u AS=0.361p AD=0.361p
+ PS=2.28u PD=2.28u
M$30 \$5 \$I131 \$11 \$1 sg13_lv_nmos L=0.16u W=1.9u AS=0.361p AD=0.646p
+ PS=2.28u PD=4.48u
.ENDS M3M4

.SUBCKT gateM1M2 \$1 \$2
X$1 \$2 \$1 via_stack$10
.ENDS gateM1M2

.SUBCKT sourceRowM1M2 \$1 \$2
X$1 \$2 \$1 via_stack$1
X$2 \$2 \$1 via_stack$1
X$3 \$2 \$1 via_stack$1
.ENDS sourceRowM1M2

.SUBCKT drainRowM1M2 \$1 \$2
X$1 \$2 \$1 via_stack$1
X$2 \$2 \$1 via_stack$1
X$3 \$2 \$1 via_stack$1
X$4 \$2 \$1 via_stack$1
.ENDS drainRowM1M2

.SUBCKT M1M2 \$1 \$2 \$3 \$5 \$6 \$7 \$9 \$12 \$I131 \$I126 \$I121 \$I116
+ \$I111 \$I106
X$1 \$5 \$3 \$1 \$I106 nmos$1
X$2 \$1 \$5 M1_conM1M2
X$3 \$1 \$3 M1_conM1M2
X$4 \$3 \$2 \$1 \$I111 nmos$1
X$5 \$1 \$2 M1_conM1M2
X$6 \$2 \$9 \$1 \$I116 nmos$1
X$7 \$1 \$9 M1_conM1M2
X$8 \$9 \$12 \$1 \$I121 nmos$1
X$9 \$1 \$12 M1_conM1M2
X$10 \$12 \$6 \$1 \$I126 nmos$1
X$11 \$1 \$6 M1_conM1M2
X$12 \$6 \$7 \$1 \$I131 nmos$1
X$13 \$1 \$7 M1_conM1M2
X$14 \$5 \$3 \$1 \$I106 nmos$1
X$15 \$1 \$5 M1_conM1M2
X$16 \$1 \$3 M1_conM1M2
X$17 \$3 \$2 \$1 \$I111 nmos$1
X$18 \$1 \$2 M1_conM1M2
X$19 \$2 \$9 \$1 \$I116 nmos$1
X$20 \$1 \$9 M1_conM1M2
X$21 \$9 \$12 \$1 \$I121 nmos$1
X$22 \$1 \$12 M1_conM1M2
X$23 \$12 \$6 \$1 \$I126 nmos$1
X$24 \$1 \$6 M1_conM1M2
X$25 \$6 \$7 \$1 \$I131 nmos$1
X$26 \$1 \$7 M1_conM1M2
X$27 \$5 \$3 \$1 \$I106 nmos$1
X$28 \$1 \$5 M1_conM1M2
X$29 \$1 \$3 M1_conM1M2
X$30 \$3 \$2 \$1 \$I111 nmos$1
X$31 \$1 \$2 M1_conM1M2
X$32 \$2 \$9 \$1 \$I116 nmos$1
X$33 \$1 \$9 M1_conM1M2
X$34 \$9 \$12 \$1 \$I121 nmos$1
X$35 \$1 \$12 M1_conM1M2
X$36 \$12 \$6 \$1 \$I126 nmos$1
X$37 \$1 \$6 M1_conM1M2
X$38 \$6 \$7 \$1 \$I131 nmos$1
X$39 \$1 \$7 M1_conM1M2
X$40 \$5 \$3 \$1 \$I106 nmos$1
X$41 \$1 \$5 M1_conM1M2
X$42 \$1 \$3 M1_conM1M2
X$43 \$3 \$2 \$1 \$I111 nmos$1
X$44 \$1 \$2 M1_conM1M2
X$45 \$2 \$9 \$1 \$I116 nmos$1
X$46 \$1 \$9 M1_conM1M2
X$47 \$9 \$12 \$1 \$I121 nmos$1
X$48 \$1 \$12 M1_conM1M2
X$49 \$12 \$6 \$1 \$I126 nmos$1
X$50 \$1 \$6 M1_conM1M2
X$51 \$6 \$7 \$1 \$I131 nmos$1
X$52 \$1 \$7 M1_conM1M2
X$53 \$5 \$3 \$1 \$I106 nmos$1
X$54 \$3 \$2 \$1 \$I111 nmos$1
X$55 \$2 \$9 \$1 \$I116 nmos$1
X$56 \$9 \$12 \$1 \$I121 nmos$1
X$57 \$12 \$6 \$1 \$I126 nmos$1
X$58 \$6 \$7 \$1 \$I131 nmos$1
M$1 \$5 \$I106 \$3 \$1 sg13_lv_nmos L=0.15u W=1.1u AS=0.374p AD=0.209p PS=2.88u
+ PD=1.48u
M$2 \$3 \$I111 \$2 \$1 sg13_lv_nmos L=0.15u W=1.1u AS=0.209p AD=0.209p PS=1.48u
+ PD=1.48u
M$3 \$2 \$I116 \$9 \$1 sg13_lv_nmos L=0.15u W=1.1u AS=0.209p AD=0.209p PS=1.48u
+ PD=1.48u
M$4 \$9 \$I121 \$12 \$1 sg13_lv_nmos L=0.15u W=1.1u AS=0.209p AD=0.209p
+ PS=1.48u PD=1.48u
M$5 \$12 \$I126 \$6 \$1 sg13_lv_nmos L=0.15u W=1.1u AS=0.209p AD=0.209p
+ PS=1.48u PD=1.48u
M$6 \$6 \$I131 \$7 \$1 sg13_lv_nmos L=0.15u W=1.1u AS=0.209p AD=0.374p PS=1.48u
+ PD=2.88u
M$7 \$5 \$I106 \$3 \$1 sg13_lv_nmos L=0.15u W=1.1u AS=0.374p AD=0.209p PS=2.88u
+ PD=1.48u
M$8 \$3 \$I111 \$2 \$1 sg13_lv_nmos L=0.15u W=1.1u AS=0.209p AD=0.209p PS=1.48u
+ PD=1.48u
M$9 \$2 \$I116 \$9 \$1 sg13_lv_nmos L=0.15u W=1.1u AS=0.209p AD=0.209p PS=1.48u
+ PD=1.48u
M$10 \$9 \$I121 \$12 \$1 sg13_lv_nmos L=0.15u W=1.1u AS=0.209p AD=0.209p
+ PS=1.48u PD=1.48u
M$11 \$12 \$I126 \$6 \$1 sg13_lv_nmos L=0.15u W=1.1u AS=0.209p AD=0.209p
+ PS=1.48u PD=1.48u
M$12 \$6 \$I131 \$7 \$1 sg13_lv_nmos L=0.15u W=1.1u AS=0.209p AD=0.374p
+ PS=1.48u PD=2.88u
M$13 \$5 \$I106 \$3 \$1 sg13_lv_nmos L=0.15u W=1.1u AS=0.374p AD=0.209p
+ PS=2.88u PD=1.48u
M$14 \$3 \$I111 \$2 \$1 sg13_lv_nmos L=0.15u W=1.1u AS=0.209p AD=0.209p
+ PS=1.48u PD=1.48u
M$15 \$2 \$I116 \$9 \$1 sg13_lv_nmos L=0.15u W=1.1u AS=0.209p AD=0.209p
+ PS=1.48u PD=1.48u
M$16 \$9 \$I121 \$12 \$1 sg13_lv_nmos L=0.15u W=1.1u AS=0.209p AD=0.209p
+ PS=1.48u PD=1.48u
M$17 \$12 \$I126 \$6 \$1 sg13_lv_nmos L=0.15u W=1.1u AS=0.209p AD=0.209p
+ PS=1.48u PD=1.48u
M$18 \$6 \$I131 \$7 \$1 sg13_lv_nmos L=0.15u W=1.1u AS=0.209p AD=0.374p
+ PS=1.48u PD=2.88u
M$19 \$5 \$I106 \$3 \$1 sg13_lv_nmos L=0.15u W=1.1u AS=0.374p AD=0.209p
+ PS=2.88u PD=1.48u
M$20 \$3 \$I111 \$2 \$1 sg13_lv_nmos L=0.15u W=1.1u AS=0.209p AD=0.209p
+ PS=1.48u PD=1.48u
M$21 \$2 \$I116 \$9 \$1 sg13_lv_nmos L=0.15u W=1.1u AS=0.209p AD=0.209p
+ PS=1.48u PD=1.48u
M$22 \$9 \$I121 \$12 \$1 sg13_lv_nmos L=0.15u W=1.1u AS=0.209p AD=0.209p
+ PS=1.48u PD=1.48u
M$23 \$12 \$I126 \$6 \$1 sg13_lv_nmos L=0.15u W=1.1u AS=0.209p AD=0.209p
+ PS=1.48u PD=1.48u
M$24 \$6 \$I131 \$7 \$1 sg13_lv_nmos L=0.15u W=1.1u AS=0.209p AD=0.374p
+ PS=1.48u PD=2.88u
M$25 \$5 \$I106 \$3 \$1 sg13_lv_nmos L=0.15u W=1.1u AS=0.374p AD=0.209p
+ PS=2.88u PD=1.48u
M$26 \$3 \$I111 \$2 \$1 sg13_lv_nmos L=0.15u W=1.1u AS=0.209p AD=0.209p
+ PS=1.48u PD=1.48u
M$27 \$2 \$I116 \$9 \$1 sg13_lv_nmos L=0.15u W=1.1u AS=0.209p AD=0.209p
+ PS=1.48u PD=1.48u
M$28 \$9 \$I121 \$12 \$1 sg13_lv_nmos L=0.15u W=1.1u AS=0.209p AD=0.209p
+ PS=1.48u PD=1.48u
M$29 \$12 \$I126 \$6 \$1 sg13_lv_nmos L=0.15u W=1.1u AS=0.209p AD=0.209p
+ PS=1.48u PD=1.48u
M$30 \$6 \$I131 \$7 \$1 sg13_lv_nmos L=0.15u W=1.1u AS=0.209p AD=0.374p
+ PS=1.48u PD=2.88u
.ENDS M1M2

.SUBCKT M0_ver_bulk \$1
X$1 \$1 M1_Cont1_NMOS
X$2 \$1 M1_Cont1_NMOS
X$3 \$1 M1_Cont1_NMOS
X$4 \$1 M1_Cont1_NMOS
X$5 \$1 M1_Cont1_NMOS
X$6 \$1 M1_Cont1_NMOS
X$7 \$1 M1_Cont1_NMOS
X$8 \$1 M1_Cont1_NMOS
.ENDS M0_ver_bulk

.SUBCKT M0_hor_bulk \$1
X$1 \$1 M1_Cont1_NMOS
X$2 \$1 M1_Cont1_NMOS
X$3 \$1 M1_Cont1_NMOS
X$4 \$1 M1_Cont1_NMOS
X$5 \$1 M1_Cont1_NMOS
X$6 \$1 M1_Cont1_NMOS
X$7 \$1 M1_Cont1_NMOS
X$8 \$1 M1_Cont1_NMOS
X$9 \$1 M1_Cont1_NMOS
X$10 \$1 M1_Cont1_NMOS
X$11 \$1 M1_Cont1_NMOS
X$12 \$1 M1_Cont1_NMOS
X$13 \$1 M1_Cont1_NMOS
X$14 \$1 M1_Cont1_NMOS
X$15 \$1 M1_Cont1_NMOS
X$16 \$1 M1_Cont1_NMOS
X$17 \$1 M1_Cont1_NMOS
X$18 \$1 M1_Cont1_NMOS
X$19 \$1 M1_Cont1_NMOS
X$20 \$1 M1_Cont1_NMOS
X$21 \$1 M1_Cont1_NMOS
X$22 \$1 M1_Cont1_NMOS
X$23 \$1 M1_Cont1_NMOS
X$24 \$1 M1_Cont1_NMOS
X$25 \$1 M1_Cont1_NMOS
X$26 \$1 M1_Cont1_NMOS
X$27 \$1 M1_Cont1_NMOS
X$28 \$1 M1_Cont1_NMOS
X$29 \$1 M1_Cont1_NMOS
X$30 \$1 M1_Cont1_NMOS
X$31 \$1 M1_Cont1_NMOS
.ENDS M0_hor_bulk

.SUBCKT M0_wRoutings \$1 \$2 \$3 \$I162
X$1 \$1 \$2 \$3 \$2 \$3 \$2 \$3 \$2 \$2 \$2 \$2 \$2 \$3 \$3 \$3 \$2 \$2 \$3 \$3
+ \$2 \$2 \$3 \$3 \$2 \$3 \$3 \$3 \$2 \$3 \$3 \$3 \$2 \$3 \$3 \$3 \$3 \$3 \$3
+ \$2 \$2 \$3 \$2 \$3 \$2 \$2 \$2 \$3 \$2 \$3 \$2 \$2 \$3 \$2 \$2 \$2 \$2
+ \$I162 \$I162 \$I162 \$I162 \$I162 \$I162 \$I162 \$I162 \$I162 \$I162 \$I162
+ \$I162 \$I162 \$I162 \$I162 \$I162 \$I162 \$I162 \$I162 \$I162 \$I162 \$I162
+ \$I162 \$I162 \$I162 \$I162 \$I162 \$I162 \$I162 \$I162 \$I162 \$I162 \$I162
+ \$I162 \$I162 \$I162 \$I162 \$I162 \$I162 \$I162 \$I162 \$I162 \$I162 \$I162
+ \$I162 \$I162 \$I162 \$I162 \$I162 \$I162 \$I162 \$I162 \$I162 \$I162 M0
X$2 \$1 \$2 metal1M0
X$3 \$1 \$2 metal1M0
X$4 \$1 \$2 metal1M0
X$5 \$1 \$2 metal1M0
X$6 \$1 \$2 metal1M0
X$7 \$1 \$2 metal1M0
X$8 \$1 \$2 metal1M0
X$9 \$1 \$2 metal1M0
X$10 \$1 \$2 metal1M0
X$11 \$1 \$2 metal1M0
X$12 \$1 \$2 metal1M0
X$13 \$1 \$2 metal1M0
X$14 \$1 \$2 metal1M0
X$15 \$1 \$2 metal1M0
X$16 \$1 \$2 metal1M0
X$17 \$1 \$2 metal1M0
X$18 \$1 \$2 metal1M0
X$19 \$1 \$2 metal1M0
X$20 \$1 \$2 metal1M0
X$21 \$1 \$2 metal1M0
X$22 \$1 \$2 metal1M0
X$23 \$1 \$2 metal1M0
X$24 \$1 \$2 metal1M0
X$25 \$1 \$2 metal1M0
X$26 \$1 \$2 metal1M0
X$27 \$1 \$2 metal1M0
X$28 \$1 \$2 metal1M0
X$29 \$1 \$2 metal1M0
X$30 \$1 \$3 metal1M0_bottom
X$31 \$1 \$3 metal1M0_bottom
X$32 \$1 \$3 metal1M0_bottom
X$33 \$1 \$3 metal1M0_bottom
X$34 \$1 \$3 metal1M0_bottom
X$35 \$1 \$3 metal1M0_bottom
X$36 \$1 \$3 metal1M0_bottom
X$37 \$1 \$3 metal1M0_bottom
X$38 \$1 \$3 metal1M0_bottom
X$39 \$1 \$3 metal1M0_bottom
X$40 \$1 \$3 metal1M0_bottom
X$41 \$1 \$3 metal1M0_bottom
X$42 \$1 \$3 metal1M0_bottom
X$43 \$1 \$3 metal1M0_bottom
X$44 \$1 \$3 metal1M0_bottom
X$45 \$1 \$3 metal1M0_bottom
X$46 \$1 \$3 metal1M0_bottom
X$47 \$1 \$3 metal1M0_bottom
X$48 \$1 \$3 metal1M0_bottom
X$49 \$1 \$3 metal1M0_bottom
X$50 \$1 \$3 metal1M0_bottom
X$51 \$1 \$3 metal1M0_bottom
X$52 \$1 \$3 metal1M0_bottom
X$53 \$1 \$3 metal1M0_bottom
X$54 \$1 \$3 metal1M0_bottom
X$55 \$1 \$3 metal1M0_bottom
X$56 \$1 \$3 metal1M0_bottom
X$57 \$1 \$I162 gateCntM0
X$58 \$1 \$I162 gateCntM0
X$59 \$1 \$I162 gateCntM0
X$60 \$1 \$I162 gateCntM0
X$61 \$1 \$I162 gateCntM0
X$62 \$1 \$I162 gateCntM0
X$63 \$1 \$I162 gateCntM0
X$64 \$1 \$I162 gateCntM0
X$65 \$1 \$I162 gateCntM0
X$66 \$1 \$I162 gateCntM0
X$67 \$1 \$I162 gateCntM0
X$68 \$1 \$I162 gateCntM0
X$69 \$1 \$I162 gateCntM0
X$70 \$1 \$I162 gateCntM0
X$71 \$1 \$I162 gateCntM0
X$72 \$1 \$I162 gateCntM0
X$73 \$1 \$I162 gateCntM0
X$74 \$1 \$I162 gateCntM0
X$75 \$1 \$I162 gateCntM0
X$76 \$1 \$I162 gateCntM0
X$77 \$1 \$I162 gateCntM0
X$78 \$1 \$I162 gateCntM0
X$79 \$1 \$I162 gateCntM0
X$80 \$1 \$I162 gateCntM0
X$81 \$1 \$I162 gateCntM0
X$82 \$1 \$I162 gateCntM0
X$83 \$1 \$I162 gateCntM0
.ENDS M0_wRoutings

.SUBCKT sourceRowM11M12 \$1 \$2
X$1 \$2 \$1 via_stack$3
X$2 \$2 \$1 via_stack$3
X$3 \$2 \$1 via_stack$3
X$4 \$2 \$1 via_stack$3
X$5 \$2 \$1 via_stack$3
X$6 \$2 \$1 via_stack$3
.ENDS sourceRowM11M12

.SUBCKT topRow \$1 \$2
X$1 \$2 \$1 via_stack$2
X$2 \$2 \$1 via_stack$2
X$3 \$2 \$1 via_stack$2
X$4 \$2 \$1 via_stack$2
X$5 \$2 \$1 via_stack$2
X$6 \$2 \$1 via_stack$2
.ENDS topRow

.SUBCKT drainRowM11M12 \$1 \$2
X$1 \$2 \$1 via_stack$3
X$2 \$2 \$1 via_stack$3
X$3 \$2 \$1 via_stack$3
X$4 \$2 \$1 via_stack$3
X$5 \$2 \$1 via_stack$3
X$6 \$2 \$1 via_stack$3
.ENDS drainRowM11M12

.SUBCKT sourceRowM11M12$1 \$1 \$2
X$1 \$2 \$1 via_stack$3
X$2 \$2 \$1 via_stack$3
X$3 \$2 \$1 via_stack$3
X$4 \$2 \$1 via_stack$3
X$5 \$2 \$1 via_stack$3
X$6 \$2 \$1 via_stack$3
.ENDS sourceRowM11M12$1

.SUBCKT topRow$1 \$1 \$2
X$1 \$2 \$1 via_stack$2
X$2 \$2 \$1 via_stack$2
X$3 \$2 \$1 via_stack$2
X$4 \$2 \$1 via_stack$2
X$5 \$2 \$1 via_stack$2
X$6 \$2 \$1 via_stack$2
.ENDS topRow$1

.SUBCKT drainRowM11M12$1 \$1 \$2
X$1 \$2 \$1 via_stack$3
X$2 \$2 \$1 via_stack$3
X$3 \$2 \$1 via_stack$3
X$4 \$2 \$1 via_stack$3
X$5 \$2 \$1 via_stack$3
X$6 \$2 \$1 via_stack$3
.ENDS drainRowM11M12$1

.SUBCKT sourceRow$1 \$1 \$2
X$1 \$2 \$1 via_stack$1
X$2 \$2 \$1 via_stack$1
X$3 \$2 \$1 via_stack$1
X$4 \$2 \$1 via_stack$1
X$5 \$2 \$1 via_stack$1
.ENDS sourceRow$1

.SUBCKT topRowM9M10$1 \$1 \$2
X$1 \$2 \$1 via_stack
X$2 \$2 \$1 via_stack
X$3 \$2 \$1 via_stack
X$4 \$2 \$1 via_stack
X$5 \$2 \$1 via_stack
X$6 \$2 \$1 via_stack
.ENDS topRowM9M10$1

.SUBCKT drainRowM9M10$1 \$1 \$2
X$1 \$2 \$1 via_stack$1
X$2 \$2 \$1 via_stack$1
X$3 \$2 \$1 via_stack$1
X$4 \$2 \$1 via_stack$1
X$5 \$2 \$1 via_stack$1
X$6 \$2 \$1 via_stack$1
.ENDS drainRowM9M10$1

.SUBCKT sourceRow \$1 \$2
X$1 \$2 \$1 via_stack$1
X$2 \$2 \$1 via_stack$1
X$3 \$2 \$1 via_stack$1
X$4 \$2 \$1 via_stack$1
X$5 \$2 \$1 via_stack$1
.ENDS sourceRow

.SUBCKT topRowM9M10 \$1 \$2
X$1 \$2 \$1 via_stack
X$2 \$2 \$1 via_stack
X$3 \$2 \$1 via_stack
X$4 \$2 \$1 via_stack
X$5 \$2 \$1 via_stack
X$6 \$2 \$1 via_stack
.ENDS topRowM9M10

.SUBCKT drainRowM9M10 \$1 \$2
X$1 \$2 \$1 via_stack$1
X$2 \$2 \$1 via_stack$1
X$3 \$2 \$1 via_stack$1
X$4 \$2 \$1 via_stack$1
X$5 \$2 \$1 via_stack$1
X$6 \$2 \$1 via_stack$1
.ENDS drainRowM9M10

.SUBCKT via_stack$6 \$1 \$2
.ENDS via_stack$6

.SUBCKT via_stack$11 \$1 \$2
.ENDS via_stack$11

.SUBCKT via_stack$8 \$1 \$2
.ENDS via_stack$8

.SUBCKT via_stack$9 \$1 \$2
.ENDS via_stack$9

.SUBCKT via_stack$7 \$1 \$2
.ENDS via_stack$7

.SUBCKT via_stack$10 \$1 \$2
.ENDS via_stack$10

.SUBCKT M1_conM11M12 \$1 \$2
.ENDS M1_conM11M12

.SUBCKT M1_conM11M12$1 \$1 \$2
.ENDS M1_conM11M12$1

.SUBCKT M1_conM3M4$1 \$1 \$2
.ENDS M1_conM3M4$1

.SUBCKT M1_conM9M10$1 \$1 \$2
.ENDS M1_conM9M10$1

.SUBCKT M1_conM5M6$1 \$1 \$2
.ENDS M1_conM5M6$1

.SUBCKT M1_conM7M8$1 \$1 \$2
.ENDS M1_conM7M8$1

.SUBCKT M1_conM1M2$1 \$1 \$2
.ENDS M1_conM1M2$1

.SUBCKT nmos$3 \$1 \$2 \$3 \$5
.ENDS nmos$3

.SUBCKT pmos$1 \$1 \$2 \$3 \$5 \$6
.ENDS pmos$1

.SUBCKT M1_conM9M10 \$1 \$2
.ENDS M1_conM9M10

.SUBCKT pmos$2 \$1 \$2 \$3 \$5 \$6
.ENDS pmos$2

.SUBCKT M1_conM5M6 \$1 \$2
.ENDS M1_conM5M6

.SUBCKT M1_conM7M8 \$1 \$2
.ENDS M1_conM7M8

.SUBCKT pmos$3 \$1 \$2 \$3 \$5 \$6
.ENDS pmos$3

.SUBCKT M1_conM3M4 \$1 \$2
.ENDS M1_conM3M4

.SUBCKT nmos$2 \$1 \$2 \$3 \$5
.ENDS nmos$2

.SUBCKT M1_conM1M2 \$1 \$2
.ENDS M1_conM1M2

.SUBCKT nmos$1 \$1 \$2 \$3 \$5
.ENDS nmos$1

.SUBCKT M1_Cont1_NMOS \$1
.ENDS M1_Cont1_NMOS

.SUBCKT gateCntM0 \$1 \$2
X$1 \$2 \$1 via_stack$4
.ENDS gateCntM0

.SUBCKT metal1M0_bottom \$1 \$2
X$1 \$2 \$1 via_stack$1
.ENDS metal1M0_bottom

.SUBCKT metal1M0 \$1 \$2
X$1 \$2 \$1 via_stack$1
.ENDS metal1M0

.SUBCKT M0 \$1 \$2 \$3 \$4 \$5 \$6 \$7 \$8 \$9 \$10 \$11 \$12 \$13 \$14 \$15
+ \$16 \$17 \$18 \$19 \$20 \$21 \$22 \$23 \$24 \$25 \$26 \$27 \$28 \$29 \$30
+ \$31 \$32 \$33 \$34 \$35 \$36 \$37 \$38 \$39 \$40 \$41 \$42 \$43 \$44 \$45
+ \$46 \$47 \$48 \$49 \$50 \$51 \$52 \$53 \$54 \$55 \$56 \$I310 \$I309 \$I308
+ \$I307 \$I306 \$I300 \$I299 \$I298 \$I297 \$I296 \$I290 \$I289 \$I288 \$I287
+ \$I286 \$I280 \$I279 \$I278 \$I277 \$I276 \$I270 \$I269 \$I268 \$I267 \$I266
+ \$I260 \$I259 \$I258 \$I257 \$I256 \$I250 \$I249 \$I248 \$I247 \$I246 \$I240
+ \$I222 \$I221 \$I220 \$I219 \$I218 \$I217 \$I216 \$I188 \$I187 \$I186 \$I185
+ \$I184 \$I24 \$I23 \$I22 \$I21 \$I20 \$I19
X$1 \$1 \$8 \$49 \$2 \$29 \$51 \$7 \$10 \$52 \$11 \$3 \$I24 \$I240 \$I216
+ \$I217 \$I218 \$I219 \$I220 \$I221 \$I222 nmos$5
X$2 \$1 \$3 \$54 \$5 \$12 \$30 \$40 \$47 \$53 \$31 \$45 \$I19 \$I184 \$I246
+ \$I256 \$I266 \$I276 \$I286 \$I296 \$I306 nmos$5
X$3 \$1 \$45 \$36 \$39 \$34 \$4 \$37 \$32 \$41 \$42 \$43 \$I20 \$I185 \$I247
+ \$I257 \$I267 \$I277 \$I287 \$I297 \$I307 nmos$5
X$4 \$1 \$43 \$28 \$15 \$16 \$35 \$17 \$33 \$56 \$27 \$44 \$I21 \$I186 \$I248
+ \$I258 \$I268 \$I278 \$I288 \$I298 \$I308 nmos$5
X$5 \$1 \$44 \$26 \$50 \$25 \$24 \$23 \$9 \$13 \$6 \$22 \$I22 \$I187 \$I249
+ \$I259 \$I269 \$I279 \$I289 \$I299 \$I309 nmos$5
X$6 \$1 \$22 \$55 \$38 \$21 \$14 \$20 \$19 \$48 \$18 \$46 \$I23 \$I188 \$I250
+ \$I260 \$I270 \$I280 \$I290 \$I300 \$I310 nmos$5
M$1 \$8 \$I24 \$49 \$1 sg13_lv_nmos L=0.2u W=3.33u AS=1.1322p AD=0.6327p
+ PS=7.34u PD=3.71u
M$2 \$49 \$I240 \$2 \$1 sg13_lv_nmos L=0.2u W=3.33u AS=0.6327p AD=0.6327p
+ PS=3.71u PD=3.71u
M$3 \$2 \$I216 \$29 \$1 sg13_lv_nmos L=0.2u W=3.33u AS=0.6327p AD=0.6327p
+ PS=3.71u PD=3.71u
M$4 \$29 \$I217 \$51 \$1 sg13_lv_nmos L=0.2u W=3.33u AS=0.6327p AD=0.6327p
+ PS=3.71u PD=3.71u
M$5 \$51 \$I218 \$7 \$1 sg13_lv_nmos L=0.2u W=3.33u AS=0.6327p AD=0.6327p
+ PS=3.71u PD=3.71u
M$6 \$7 \$I219 \$10 \$1 sg13_lv_nmos L=0.2u W=3.33u AS=0.6327p AD=0.6327p
+ PS=3.71u PD=3.71u
M$7 \$10 \$I220 \$52 \$1 sg13_lv_nmos L=0.2u W=3.33u AS=0.6327p AD=0.6327p
+ PS=3.71u PD=3.71u
M$8 \$52 \$I221 \$11 \$1 sg13_lv_nmos L=0.2u W=3.33u AS=0.6327p AD=0.6327p
+ PS=3.71u PD=3.71u
M$9 \$11 \$I222 \$3 \$1 sg13_lv_nmos L=0.2u W=3.33u AS=0.6327p AD=0.6327p
+ PS=3.71u PD=3.71u
M$10 \$3 \$I19 \$54 \$1 sg13_lv_nmos L=0.2u W=3.33u AS=0.6327p AD=0.6327p
+ PS=3.71u PD=3.71u
M$11 \$54 \$I184 \$5 \$1 sg13_lv_nmos L=0.2u W=3.33u AS=0.6327p AD=0.6327p
+ PS=3.71u PD=3.71u
M$12 \$5 \$I246 \$12 \$1 sg13_lv_nmos L=0.2u W=3.33u AS=0.6327p AD=0.6327p
+ PS=3.71u PD=3.71u
M$13 \$12 \$I256 \$30 \$1 sg13_lv_nmos L=0.2u W=3.33u AS=0.6327p AD=0.6327p
+ PS=3.71u PD=3.71u
M$14 \$30 \$I266 \$40 \$1 sg13_lv_nmos L=0.2u W=3.33u AS=0.6327p AD=0.6327p
+ PS=3.71u PD=3.71u
M$15 \$40 \$I276 \$47 \$1 sg13_lv_nmos L=0.2u W=3.33u AS=0.6327p AD=0.6327p
+ PS=3.71u PD=3.71u
M$16 \$47 \$I286 \$53 \$1 sg13_lv_nmos L=0.2u W=3.33u AS=0.6327p AD=0.6327p
+ PS=3.71u PD=3.71u
M$17 \$53 \$I296 \$31 \$1 sg13_lv_nmos L=0.2u W=3.33u AS=0.6327p AD=0.6327p
+ PS=3.71u PD=3.71u
M$18 \$31 \$I306 \$45 \$1 sg13_lv_nmos L=0.2u W=3.33u AS=0.6327p AD=0.6327p
+ PS=3.71u PD=3.71u
M$19 \$45 \$I20 \$36 \$1 sg13_lv_nmos L=0.2u W=3.33u AS=0.6327p AD=0.6327p
+ PS=3.71u PD=3.71u
M$20 \$36 \$I185 \$39 \$1 sg13_lv_nmos L=0.2u W=3.33u AS=0.6327p AD=0.6327p
+ PS=3.71u PD=3.71u
M$21 \$39 \$I247 \$34 \$1 sg13_lv_nmos L=0.2u W=3.33u AS=0.6327p AD=0.6327p
+ PS=3.71u PD=3.71u
M$22 \$34 \$I257 \$4 \$1 sg13_lv_nmos L=0.2u W=3.33u AS=0.6327p AD=0.6327p
+ PS=3.71u PD=3.71u
M$23 \$4 \$I267 \$37 \$1 sg13_lv_nmos L=0.2u W=3.33u AS=0.6327p AD=0.6327p
+ PS=3.71u PD=3.71u
M$24 \$37 \$I277 \$32 \$1 sg13_lv_nmos L=0.2u W=3.33u AS=0.6327p AD=0.6327p
+ PS=3.71u PD=3.71u
M$25 \$32 \$I287 \$41 \$1 sg13_lv_nmos L=0.2u W=3.33u AS=0.6327p AD=0.6327p
+ PS=3.71u PD=3.71u
M$26 \$41 \$I297 \$42 \$1 sg13_lv_nmos L=0.2u W=3.33u AS=0.6327p AD=0.6327p
+ PS=3.71u PD=3.71u
M$27 \$42 \$I307 \$43 \$1 sg13_lv_nmos L=0.2u W=3.33u AS=0.6327p AD=0.6327p
+ PS=3.71u PD=3.71u
M$28 \$43 \$I21 \$28 \$1 sg13_lv_nmos L=0.2u W=3.33u AS=0.6327p AD=0.6327p
+ PS=3.71u PD=3.71u
M$29 \$28 \$I186 \$15 \$1 sg13_lv_nmos L=0.2u W=3.33u AS=0.6327p AD=0.6327p
+ PS=3.71u PD=3.71u
M$30 \$15 \$I248 \$16 \$1 sg13_lv_nmos L=0.2u W=3.33u AS=0.6327p AD=0.6327p
+ PS=3.71u PD=3.71u
M$31 \$16 \$I258 \$35 \$1 sg13_lv_nmos L=0.2u W=3.33u AS=0.6327p AD=0.6327p
+ PS=3.71u PD=3.71u
M$32 \$35 \$I268 \$17 \$1 sg13_lv_nmos L=0.2u W=3.33u AS=0.6327p AD=0.6327p
+ PS=3.71u PD=3.71u
M$33 \$17 \$I278 \$33 \$1 sg13_lv_nmos L=0.2u W=3.33u AS=0.6327p AD=0.6327p
+ PS=3.71u PD=3.71u
M$34 \$33 \$I288 \$56 \$1 sg13_lv_nmos L=0.2u W=3.33u AS=0.6327p AD=0.6327p
+ PS=3.71u PD=3.71u
M$35 \$56 \$I298 \$27 \$1 sg13_lv_nmos L=0.2u W=3.33u AS=0.6327p AD=0.6327p
+ PS=3.71u PD=3.71u
M$36 \$27 \$I308 \$44 \$1 sg13_lv_nmos L=0.2u W=3.33u AS=0.6327p AD=0.6327p
+ PS=3.71u PD=3.71u
M$37 \$44 \$I22 \$26 \$1 sg13_lv_nmos L=0.2u W=3.33u AS=0.6327p AD=0.6327p
+ PS=3.71u PD=3.71u
M$38 \$26 \$I187 \$50 \$1 sg13_lv_nmos L=0.2u W=3.33u AS=0.6327p AD=0.6327p
+ PS=3.71u PD=3.71u
M$39 \$50 \$I249 \$25 \$1 sg13_lv_nmos L=0.2u W=3.33u AS=0.6327p AD=0.6327p
+ PS=3.71u PD=3.71u
M$40 \$25 \$I259 \$24 \$1 sg13_lv_nmos L=0.2u W=3.33u AS=0.6327p AD=0.6327p
+ PS=3.71u PD=3.71u
M$41 \$24 \$I269 \$23 \$1 sg13_lv_nmos L=0.2u W=3.33u AS=0.6327p AD=0.6327p
+ PS=3.71u PD=3.71u
M$42 \$23 \$I279 \$9 \$1 sg13_lv_nmos L=0.2u W=3.33u AS=0.6327p AD=0.6327p
+ PS=3.71u PD=3.71u
M$43 \$9 \$I289 \$13 \$1 sg13_lv_nmos L=0.2u W=3.33u AS=0.6327p AD=0.6327p
+ PS=3.71u PD=3.71u
M$44 \$13 \$I299 \$6 \$1 sg13_lv_nmos L=0.2u W=3.33u AS=0.6327p AD=0.6327p
+ PS=3.71u PD=3.71u
M$45 \$6 \$I309 \$22 \$1 sg13_lv_nmos L=0.2u W=3.33u AS=0.6327p AD=0.6327p
+ PS=3.71u PD=3.71u
M$46 \$22 \$I23 \$55 \$1 sg13_lv_nmos L=0.2u W=3.33u AS=0.6327p AD=0.6327p
+ PS=3.71u PD=3.71u
M$47 \$55 \$I188 \$38 \$1 sg13_lv_nmos L=0.2u W=3.33u AS=0.6327p AD=0.6327p
+ PS=3.71u PD=3.71u
M$48 \$38 \$I250 \$21 \$1 sg13_lv_nmos L=0.2u W=3.33u AS=0.6327p AD=0.6327p
+ PS=3.71u PD=3.71u
M$49 \$21 \$I260 \$14 \$1 sg13_lv_nmos L=0.2u W=3.33u AS=0.6327p AD=0.6327p
+ PS=3.71u PD=3.71u
M$50 \$14 \$I270 \$20 \$1 sg13_lv_nmos L=0.2u W=3.33u AS=0.6327p AD=0.6327p
+ PS=3.71u PD=3.71u
M$51 \$20 \$I280 \$19 \$1 sg13_lv_nmos L=0.2u W=3.33u AS=0.6327p AD=0.6327p
+ PS=3.71u PD=3.71u
M$52 \$19 \$I290 \$48 \$1 sg13_lv_nmos L=0.2u W=3.33u AS=0.6327p AD=0.6327p
+ PS=3.71u PD=3.71u
M$53 \$48 \$I300 \$18 \$1 sg13_lv_nmos L=0.2u W=3.33u AS=0.6327p AD=0.6327p
+ PS=3.71u PD=3.71u
M$54 \$18 \$I310 \$46 \$1 sg13_lv_nmos L=0.2u W=3.33u AS=0.6327p AD=1.1322p
+ PS=3.71u PD=7.34u
.ENDS M0

.SUBCKT via_stack$2 \$1 \$2
.ENDS via_stack$2

.SUBCKT via_stack$3 \$1 \$2
.ENDS via_stack$3

.SUBCKT via_stack$4 \$1 \$2
.ENDS via_stack$4

.SUBCKT via_stack$1 \$1 \$2
.ENDS via_stack$1

.SUBCKT via_stack \$1 \$2
.ENDS via_stack

.SUBCKT nmos$5 \$1 \$2 \$3 \$4 \$5 \$6 \$7 \$8 \$9 \$10 \$11 \$13 \$14 \$15
+ \$16 \$17 \$18 \$19 \$20 \$21
.ENDS nmos$5
